

{
    name: "kraken_padframe_aon_config"
    clock_primary: "clk_i"
    reset_primary: "rst_ni"
    bus_interfaces: [
        { protocol: "reg_iface", direction: "device"}
    ]
    regwidth: 32,
    registers: [
        {skipto: "0x0"},
        {
            name: INFO
            desc: "Read-only IP Information register"
            swaccess: "ro"
            hwaccess: "hro"
            fields: [
              {
                bits: "15:0"
                name: HW_VERSION
                desc: "Hardware version ID."
                resval: 2
              },
              {
                  bits:"31:16"
                  name: PADCOUNT
                  desc: "The number of muxable pads in this IP."
                  resval: "42"
              }
            ]
        }



























      {
          name: PAD_GPIOA0_CFG
          desc: '''
            Pad signal configuration.
          '''
          swaccess: "rw"
          fields: [
            {
                bits: "0"
                name: chip2pad
                desc: '''
                     The signal that connects to the pads TX driver
                '''
                swaccess: "rw"
                hwaccess: "hro"
                resval: "0"
            },
            {
                bits: "2:1"
                name: drv
                desc: '''
                     Driving strength selector
                '''
                swaccess: "rw"
                hwaccess: "hro"
                resval: "3"
            },
            {
                bits: "3"
                name: pde
                desc: '''
                     Pull down resistor enable
                '''
                swaccess: "rw"
                hwaccess: "hro"
                resval: "0"
            },
            {
                bits: "4"
                name: pue
                desc: '''
                     Pull up resistor enable
                '''
                swaccess: "rw"
                hwaccess: "hro"
                resval: "0"
            },
            {
                bits: "5"
                name: rxe
                desc: '''
                     Active high RX driver enable 
                '''
                swaccess: "rw"
                hwaccess: "hro"
                resval: "1"
            },
            {
                bits: "6"
                name: slw
                desc: '''
                     
                '''
                swaccess: "rw"
                hwaccess: "hro"
                resval: "0"
            },
            {
                bits: "7"
                name: smt
                desc: '''
                     Schmit trigger enable
                '''
                swaccess: "rw"
                hwaccess: "hro"
                resval: "0"
            },
            {
                bits: "8"
                name: trie
                desc: '''
                      Active high tri-state enable (active low TX driver enable)
                '''
                swaccess: "rw"
                hwaccess: "hro"
                resval: "1"
            },
          ]
      }

       {
          name: PAD_GPIOA0_MUX_SEL
          desc: '''
              Pad signal port multiplex selection for pad pad_gpioa0. The programmed value defines which port
              is connected to the pad.
          '''
          swaccess: "rw"
          hwaccess: "hro"
          resval: 0
          fields: [
              {
                  name: sel
                  desc: "Port selection index for pad pad_gpioa0."
                  bits: "5:0"
                  enum: [
                      { value: "0", name: "register", desc: "Connects the Pad to the internal configuration register."}
                      { value: "1", name: "port_dvsi0_are", desc: "Connect port are from port group dvsi0 to this pad." }
                      { value: "2", name: "port_dvsi0_asa", desc: "Connect port asa from port group dvsi0 to this pad." }
                      { value: "3", name: "port_dvsi0_asy", desc: "Connect port asy from port group dvsi0 to this pad." }
                      { value: "4", name: "port_dvsi0_cfg0", desc: "Connect port cfg0 from port group dvsi0 to this pad." }
                      { value: "5", name: "port_dvsi0_cfg1", desc: "Connect port cfg1 from port group dvsi0 to this pad." }
                      { value: "6", name: "port_dvsi0_cfg2", desc: "Connect port cfg2 from port group dvsi0 to this pad." }
                      { value: "7", name: "port_dvsi0_cfg3", desc: "Connect port cfg3 from port group dvsi0 to this pad." }
                      { value: "8", name: "port_dvsi0_cfg4", desc: "Connect port cfg4 from port group dvsi0 to this pad." }
                      { value: "9", name: "port_dvsi0_cfg5", desc: "Connect port cfg5 from port group dvsi0 to this pad." }
                      { value: "10", name: "port_dvsi0_cfg6", desc: "Connect port cfg6 from port group dvsi0 to this pad." }
                      { value: "11", name: "port_dvsi0_cfg7", desc: "Connect port cfg7 from port group dvsi0 to this pad." }
                      { value: "12", name: "port_dvsi0_off0", desc: "Connect port off0 from port group dvsi0 to this pad." }
                      { value: "13", name: "port_dvsi0_off1", desc: "Connect port off1 from port group dvsi0 to this pad." }
                      { value: "14", name: "port_dvsi0_off2", desc: "Connect port off2 from port group dvsi0 to this pad." }
                      { value: "15", name: "port_dvsi0_off3", desc: "Connect port off3 from port group dvsi0 to this pad." }
                      { value: "16", name: "port_dvsi0_on0", desc: "Connect port on0 from port group dvsi0 to this pad." }
                      { value: "17", name: "port_dvsi0_on1", desc: "Connect port on1 from port group dvsi0 to this pad." }
                      { value: "18", name: "port_dvsi0_on2", desc: "Connect port on2 from port group dvsi0 to this pad." }
                      { value: "19", name: "port_dvsi0_on3", desc: "Connect port on3 from port group dvsi0 to this pad." }
                      { value: "20", name: "port_dvsi0_sxy", desc: "Connect port sxy from port group dvsi0 to this pad." }
                      { value: "21", name: "port_dvsi0_xclk", desc: "Connect port xclk from port group dvsi0 to this pad." }
                      { value: "22", name: "port_dvsi0_xnrst", desc: "Connect port xnrst from port group dvsi0 to this pad." }
                      { value: "23", name: "port_dvsi0_xydata0", desc: "Connect port xydata0 from port group dvsi0 to this pad." }
                      { value: "24", name: "port_dvsi0_xydata1", desc: "Connect port xydata1 from port group dvsi0 to this pad." }
                      { value: "25", name: "port_dvsi0_xydata2", desc: "Connect port xydata2 from port group dvsi0 to this pad." }
                      { value: "26", name: "port_dvsi0_xydata3", desc: "Connect port xydata3 from port group dvsi0 to this pad." }
                      { value: "27", name: "port_dvsi0_xydata4", desc: "Connect port xydata4 from port group dvsi0 to this pad." }
                      { value: "28", name: "port_dvsi0_xydata5", desc: "Connect port xydata5 from port group dvsi0 to this pad." }
                      { value: "29", name: "port_dvsi0_xydata6", desc: "Connect port xydata6 from port group dvsi0 to this pad." }
                      { value: "30", name: "port_dvsi0_xydata7", desc: "Connect port xydata7 from port group dvsi0 to this pad." }
                      { value: "31", name: "port_dvsi0_yclk", desc: "Connect port yclk from port group dvsi0 to this pad." }
                      { value: "32", name: "port_dvsi0_ynrst", desc: "Connect port ynrst from port group dvsi0 to this pad." }
                      { value: "33", name: "port_gpio_a_gpio0", desc: "Connect port gpio0 from port group gpio_a to this pad." }
                      { value: "34", name: "port_i2c0_i2c_scl", desc: "Connect port i2c_scl from port group i2c0 to this pad." }
                      { value: "35", name: "port_i2c0_i2c_sda", desc: "Connect port i2c_sda from port group i2c0 to this pad." }
                      { value: "36", name: "port_i2c1_i2c_scl", desc: "Connect port i2c_scl from port group i2c1 to this pad." }
                      { value: "37", name: "port_i2c1_i2c_sda", desc: "Connect port i2c_sda from port group i2c1 to this pad." }
                      { value: "38", name: "port_i2c2_i2c_scl", desc: "Connect port i2c_scl from port group i2c2 to this pad." }
                      { value: "39", name: "port_i2c2_i2c_sda", desc: "Connect port i2c_sda from port group i2c2 to this pad." }
                      { value: "40", name: "port_i2c3_i2c_scl", desc: "Connect port i2c_scl from port group i2c3 to this pad." }
                      { value: "41", name: "port_i2c3_i2c_sda", desc: "Connect port i2c_sda from port group i2c3 to this pad." }
                      { value: "42", name: "port_uart0_rx", desc: "Connect port rx from port group uart0 to this pad." }
                      { value: "43", name: "port_uart0_tx", desc: "Connect port tx from port group uart0 to this pad." }
                      { value: "44", name: "port_uart1_rx", desc: "Connect port rx from port group uart1 to this pad." }
                      { value: "45", name: "port_uart1_tx", desc: "Connect port tx from port group uart1 to this pad." }
                  ]
              }
          ]
      }

      {
          name: PAD_GPIOA1_CFG
          desc: '''
            Pad signal configuration.
          '''
          swaccess: "rw"
          fields: [
            {
                bits: "0"
                name: chip2pad
                desc: '''
                     The signal that connects to the pads TX driver
                '''
                swaccess: "rw"
                hwaccess: "hro"
                resval: "0"
            },
            {
                bits: "2:1"
                name: drv
                desc: '''
                     Driving strength selector
                '''
                swaccess: "rw"
                hwaccess: "hro"
                resval: "3"
            },
            {
                bits: "3"
                name: pde
                desc: '''
                     Pull down resistor enable
                '''
                swaccess: "rw"
                hwaccess: "hro"
                resval: "0"
            },
            {
                bits: "4"
                name: pue
                desc: '''
                     Pull up resistor enable
                '''
                swaccess: "rw"
                hwaccess: "hro"
                resval: "0"
            },
            {
                bits: "5"
                name: rxe
                desc: '''
                     Active high RX driver enable 
                '''
                swaccess: "rw"
                hwaccess: "hro"
                resval: "1"
            },
            {
                bits: "6"
                name: slw
                desc: '''
                     
                '''
                swaccess: "rw"
                hwaccess: "hro"
                resval: "0"
            },
            {
                bits: "7"
                name: smt
                desc: '''
                     Schmit trigger enable
                '''
                swaccess: "rw"
                hwaccess: "hro"
                resval: "0"
            },
            {
                bits: "8"
                name: trie
                desc: '''
                      Active high tri-state enable (active low TX driver enable)
                '''
                swaccess: "rw"
                hwaccess: "hro"
                resval: "1"
            },
          ]
      }

       {
          name: PAD_GPIOA1_MUX_SEL
          desc: '''
              Pad signal port multiplex selection for pad pad_gpioa1. The programmed value defines which port
              is connected to the pad.
          '''
          swaccess: "rw"
          hwaccess: "hro"
          resval: 0
          fields: [
              {
                  name: sel
                  desc: "Port selection index for pad pad_gpioa1."
                  bits: "5:0"
                  enum: [
                      { value: "0", name: "register", desc: "Connects the Pad to the internal configuration register."}
                      { value: "1", name: "port_dvsi0_are", desc: "Connect port are from port group dvsi0 to this pad." }
                      { value: "2", name: "port_dvsi0_asa", desc: "Connect port asa from port group dvsi0 to this pad." }
                      { value: "3", name: "port_dvsi0_asy", desc: "Connect port asy from port group dvsi0 to this pad." }
                      { value: "4", name: "port_dvsi0_cfg0", desc: "Connect port cfg0 from port group dvsi0 to this pad." }
                      { value: "5", name: "port_dvsi0_cfg1", desc: "Connect port cfg1 from port group dvsi0 to this pad." }
                      { value: "6", name: "port_dvsi0_cfg2", desc: "Connect port cfg2 from port group dvsi0 to this pad." }
                      { value: "7", name: "port_dvsi0_cfg3", desc: "Connect port cfg3 from port group dvsi0 to this pad." }
                      { value: "8", name: "port_dvsi0_cfg4", desc: "Connect port cfg4 from port group dvsi0 to this pad." }
                      { value: "9", name: "port_dvsi0_cfg5", desc: "Connect port cfg5 from port group dvsi0 to this pad." }
                      { value: "10", name: "port_dvsi0_cfg6", desc: "Connect port cfg6 from port group dvsi0 to this pad." }
                      { value: "11", name: "port_dvsi0_cfg7", desc: "Connect port cfg7 from port group dvsi0 to this pad." }
                      { value: "12", name: "port_dvsi0_off0", desc: "Connect port off0 from port group dvsi0 to this pad." }
                      { value: "13", name: "port_dvsi0_off1", desc: "Connect port off1 from port group dvsi0 to this pad." }
                      { value: "14", name: "port_dvsi0_off2", desc: "Connect port off2 from port group dvsi0 to this pad." }
                      { value: "15", name: "port_dvsi0_off3", desc: "Connect port off3 from port group dvsi0 to this pad." }
                      { value: "16", name: "port_dvsi0_on0", desc: "Connect port on0 from port group dvsi0 to this pad." }
                      { value: "17", name: "port_dvsi0_on1", desc: "Connect port on1 from port group dvsi0 to this pad." }
                      { value: "18", name: "port_dvsi0_on2", desc: "Connect port on2 from port group dvsi0 to this pad." }
                      { value: "19", name: "port_dvsi0_on3", desc: "Connect port on3 from port group dvsi0 to this pad." }
                      { value: "20", name: "port_dvsi0_sxy", desc: "Connect port sxy from port group dvsi0 to this pad." }
                      { value: "21", name: "port_dvsi0_xclk", desc: "Connect port xclk from port group dvsi0 to this pad." }
                      { value: "22", name: "port_dvsi0_xnrst", desc: "Connect port xnrst from port group dvsi0 to this pad." }
                      { value: "23", name: "port_dvsi0_xydata0", desc: "Connect port xydata0 from port group dvsi0 to this pad." }
                      { value: "24", name: "port_dvsi0_xydata1", desc: "Connect port xydata1 from port group dvsi0 to this pad." }
                      { value: "25", name: "port_dvsi0_xydata2", desc: "Connect port xydata2 from port group dvsi0 to this pad." }
                      { value: "26", name: "port_dvsi0_xydata3", desc: "Connect port xydata3 from port group dvsi0 to this pad." }
                      { value: "27", name: "port_dvsi0_xydata4", desc: "Connect port xydata4 from port group dvsi0 to this pad." }
                      { value: "28", name: "port_dvsi0_xydata5", desc: "Connect port xydata5 from port group dvsi0 to this pad." }
                      { value: "29", name: "port_dvsi0_xydata6", desc: "Connect port xydata6 from port group dvsi0 to this pad." }
                      { value: "30", name: "port_dvsi0_xydata7", desc: "Connect port xydata7 from port group dvsi0 to this pad." }
                      { value: "31", name: "port_dvsi0_yclk", desc: "Connect port yclk from port group dvsi0 to this pad." }
                      { value: "32", name: "port_dvsi0_ynrst", desc: "Connect port ynrst from port group dvsi0 to this pad." }
                      { value: "33", name: "port_gpio_a_gpio1", desc: "Connect port gpio1 from port group gpio_a to this pad." }
                      { value: "34", name: "port_i2c0_i2c_scl", desc: "Connect port i2c_scl from port group i2c0 to this pad." }
                      { value: "35", name: "port_i2c0_i2c_sda", desc: "Connect port i2c_sda from port group i2c0 to this pad." }
                      { value: "36", name: "port_i2c1_i2c_scl", desc: "Connect port i2c_scl from port group i2c1 to this pad." }
                      { value: "37", name: "port_i2c1_i2c_sda", desc: "Connect port i2c_sda from port group i2c1 to this pad." }
                      { value: "38", name: "port_i2c2_i2c_scl", desc: "Connect port i2c_scl from port group i2c2 to this pad." }
                      { value: "39", name: "port_i2c2_i2c_sda", desc: "Connect port i2c_sda from port group i2c2 to this pad." }
                      { value: "40", name: "port_i2c3_i2c_scl", desc: "Connect port i2c_scl from port group i2c3 to this pad." }
                      { value: "41", name: "port_i2c3_i2c_sda", desc: "Connect port i2c_sda from port group i2c3 to this pad." }
                      { value: "42", name: "port_uart0_rx", desc: "Connect port rx from port group uart0 to this pad." }
                      { value: "43", name: "port_uart0_tx", desc: "Connect port tx from port group uart0 to this pad." }
                      { value: "44", name: "port_uart1_rx", desc: "Connect port rx from port group uart1 to this pad." }
                      { value: "45", name: "port_uart1_tx", desc: "Connect port tx from port group uart1 to this pad." }
                  ]
              }
          ]
      }

      {
          name: PAD_GPIOA2_CFG
          desc: '''
            Pad signal configuration.
          '''
          swaccess: "rw"
          fields: [
            {
                bits: "0"
                name: chip2pad
                desc: '''
                     The signal that connects to the pads TX driver
                '''
                swaccess: "rw"
                hwaccess: "hro"
                resval: "0"
            },
            {
                bits: "2:1"
                name: drv
                desc: '''
                     Driving strength selector
                '''
                swaccess: "rw"
                hwaccess: "hro"
                resval: "3"
            },
            {
                bits: "3"
                name: pde
                desc: '''
                     Pull down resistor enable
                '''
                swaccess: "rw"
                hwaccess: "hro"
                resval: "0"
            },
            {
                bits: "4"
                name: pue
                desc: '''
                     Pull up resistor enable
                '''
                swaccess: "rw"
                hwaccess: "hro"
                resval: "0"
            },
            {
                bits: "5"
                name: rxe
                desc: '''
                     Active high RX driver enable 
                '''
                swaccess: "rw"
                hwaccess: "hro"
                resval: "1"
            },
            {
                bits: "6"
                name: slw
                desc: '''
                     
                '''
                swaccess: "rw"
                hwaccess: "hro"
                resval: "0"
            },
            {
                bits: "7"
                name: smt
                desc: '''
                     Schmit trigger enable
                '''
                swaccess: "rw"
                hwaccess: "hro"
                resval: "0"
            },
            {
                bits: "8"
                name: trie
                desc: '''
                      Active high tri-state enable (active low TX driver enable)
                '''
                swaccess: "rw"
                hwaccess: "hro"
                resval: "1"
            },
          ]
      }

       {
          name: PAD_GPIOA2_MUX_SEL
          desc: '''
              Pad signal port multiplex selection for pad pad_gpioa2. The programmed value defines which port
              is connected to the pad.
          '''
          swaccess: "rw"
          hwaccess: "hro"
          resval: 0
          fields: [
              {
                  name: sel
                  desc: "Port selection index for pad pad_gpioa2."
                  bits: "5:0"
                  enum: [
                      { value: "0", name: "register", desc: "Connects the Pad to the internal configuration register."}
                      { value: "1", name: "port_dvsi0_are", desc: "Connect port are from port group dvsi0 to this pad." }
                      { value: "2", name: "port_dvsi0_asa", desc: "Connect port asa from port group dvsi0 to this pad." }
                      { value: "3", name: "port_dvsi0_asy", desc: "Connect port asy from port group dvsi0 to this pad." }
                      { value: "4", name: "port_dvsi0_cfg0", desc: "Connect port cfg0 from port group dvsi0 to this pad." }
                      { value: "5", name: "port_dvsi0_cfg1", desc: "Connect port cfg1 from port group dvsi0 to this pad." }
                      { value: "6", name: "port_dvsi0_cfg2", desc: "Connect port cfg2 from port group dvsi0 to this pad." }
                      { value: "7", name: "port_dvsi0_cfg3", desc: "Connect port cfg3 from port group dvsi0 to this pad." }
                      { value: "8", name: "port_dvsi0_cfg4", desc: "Connect port cfg4 from port group dvsi0 to this pad." }
                      { value: "9", name: "port_dvsi0_cfg5", desc: "Connect port cfg5 from port group dvsi0 to this pad." }
                      { value: "10", name: "port_dvsi0_cfg6", desc: "Connect port cfg6 from port group dvsi0 to this pad." }
                      { value: "11", name: "port_dvsi0_cfg7", desc: "Connect port cfg7 from port group dvsi0 to this pad." }
                      { value: "12", name: "port_dvsi0_off0", desc: "Connect port off0 from port group dvsi0 to this pad." }
                      { value: "13", name: "port_dvsi0_off1", desc: "Connect port off1 from port group dvsi0 to this pad." }
                      { value: "14", name: "port_dvsi0_off2", desc: "Connect port off2 from port group dvsi0 to this pad." }
                      { value: "15", name: "port_dvsi0_off3", desc: "Connect port off3 from port group dvsi0 to this pad." }
                      { value: "16", name: "port_dvsi0_on0", desc: "Connect port on0 from port group dvsi0 to this pad." }
                      { value: "17", name: "port_dvsi0_on1", desc: "Connect port on1 from port group dvsi0 to this pad." }
                      { value: "18", name: "port_dvsi0_on2", desc: "Connect port on2 from port group dvsi0 to this pad." }
                      { value: "19", name: "port_dvsi0_on3", desc: "Connect port on3 from port group dvsi0 to this pad." }
                      { value: "20", name: "port_dvsi0_sxy", desc: "Connect port sxy from port group dvsi0 to this pad." }
                      { value: "21", name: "port_dvsi0_xclk", desc: "Connect port xclk from port group dvsi0 to this pad." }
                      { value: "22", name: "port_dvsi0_xnrst", desc: "Connect port xnrst from port group dvsi0 to this pad." }
                      { value: "23", name: "port_dvsi0_xydata0", desc: "Connect port xydata0 from port group dvsi0 to this pad." }
                      { value: "24", name: "port_dvsi0_xydata1", desc: "Connect port xydata1 from port group dvsi0 to this pad." }
                      { value: "25", name: "port_dvsi0_xydata2", desc: "Connect port xydata2 from port group dvsi0 to this pad." }
                      { value: "26", name: "port_dvsi0_xydata3", desc: "Connect port xydata3 from port group dvsi0 to this pad." }
                      { value: "27", name: "port_dvsi0_xydata4", desc: "Connect port xydata4 from port group dvsi0 to this pad." }
                      { value: "28", name: "port_dvsi0_xydata5", desc: "Connect port xydata5 from port group dvsi0 to this pad." }
                      { value: "29", name: "port_dvsi0_xydata6", desc: "Connect port xydata6 from port group dvsi0 to this pad." }
                      { value: "30", name: "port_dvsi0_xydata7", desc: "Connect port xydata7 from port group dvsi0 to this pad." }
                      { value: "31", name: "port_dvsi0_yclk", desc: "Connect port yclk from port group dvsi0 to this pad." }
                      { value: "32", name: "port_dvsi0_ynrst", desc: "Connect port ynrst from port group dvsi0 to this pad." }
                      { value: "33", name: "port_gpio_a_gpio2", desc: "Connect port gpio2 from port group gpio_a to this pad." }
                      { value: "34", name: "port_i2c0_i2c_scl", desc: "Connect port i2c_scl from port group i2c0 to this pad." }
                      { value: "35", name: "port_i2c0_i2c_sda", desc: "Connect port i2c_sda from port group i2c0 to this pad." }
                      { value: "36", name: "port_i2c1_i2c_scl", desc: "Connect port i2c_scl from port group i2c1 to this pad." }
                      { value: "37", name: "port_i2c1_i2c_sda", desc: "Connect port i2c_sda from port group i2c1 to this pad." }
                      { value: "38", name: "port_i2c2_i2c_scl", desc: "Connect port i2c_scl from port group i2c2 to this pad." }
                      { value: "39", name: "port_i2c2_i2c_sda", desc: "Connect port i2c_sda from port group i2c2 to this pad." }
                      { value: "40", name: "port_i2c3_i2c_scl", desc: "Connect port i2c_scl from port group i2c3 to this pad." }
                      { value: "41", name: "port_i2c3_i2c_sda", desc: "Connect port i2c_sda from port group i2c3 to this pad." }
                      { value: "42", name: "port_uart0_rx", desc: "Connect port rx from port group uart0 to this pad." }
                      { value: "43", name: "port_uart0_tx", desc: "Connect port tx from port group uart0 to this pad." }
                      { value: "44", name: "port_uart1_rx", desc: "Connect port rx from port group uart1 to this pad." }
                      { value: "45", name: "port_uart1_tx", desc: "Connect port tx from port group uart1 to this pad." }
                  ]
              }
          ]
      }

      {
          name: PAD_GPIOA3_CFG
          desc: '''
            Pad signal configuration.
          '''
          swaccess: "rw"
          fields: [
            {
                bits: "0"
                name: chip2pad
                desc: '''
                     The signal that connects to the pads TX driver
                '''
                swaccess: "rw"
                hwaccess: "hro"
                resval: "0"
            },
            {
                bits: "2:1"
                name: drv
                desc: '''
                     Driving strength selector
                '''
                swaccess: "rw"
                hwaccess: "hro"
                resval: "3"
            },
            {
                bits: "3"
                name: pde
                desc: '''
                     Pull down resistor enable
                '''
                swaccess: "rw"
                hwaccess: "hro"
                resval: "0"
            },
            {
                bits: "4"
                name: pue
                desc: '''
                     Pull up resistor enable
                '''
                swaccess: "rw"
                hwaccess: "hro"
                resval: "0"
            },
            {
                bits: "5"
                name: rxe
                desc: '''
                     Active high RX driver enable 
                '''
                swaccess: "rw"
                hwaccess: "hro"
                resval: "1"
            },
            {
                bits: "6"
                name: slw
                desc: '''
                     
                '''
                swaccess: "rw"
                hwaccess: "hro"
                resval: "0"
            },
            {
                bits: "7"
                name: smt
                desc: '''
                     Schmit trigger enable
                '''
                swaccess: "rw"
                hwaccess: "hro"
                resval: "0"
            },
            {
                bits: "8"
                name: trie
                desc: '''
                      Active high tri-state enable (active low TX driver enable)
                '''
                swaccess: "rw"
                hwaccess: "hro"
                resval: "1"
            },
          ]
      }

       {
          name: PAD_GPIOA3_MUX_SEL
          desc: '''
              Pad signal port multiplex selection for pad pad_gpioa3. The programmed value defines which port
              is connected to the pad.
          '''
          swaccess: "rw"
          hwaccess: "hro"
          resval: 0
          fields: [
              {
                  name: sel
                  desc: "Port selection index for pad pad_gpioa3."
                  bits: "5:0"
                  enum: [
                      { value: "0", name: "register", desc: "Connects the Pad to the internal configuration register."}
                      { value: "1", name: "port_dvsi0_are", desc: "Connect port are from port group dvsi0 to this pad." }
                      { value: "2", name: "port_dvsi0_asa", desc: "Connect port asa from port group dvsi0 to this pad." }
                      { value: "3", name: "port_dvsi0_asy", desc: "Connect port asy from port group dvsi0 to this pad." }
                      { value: "4", name: "port_dvsi0_cfg0", desc: "Connect port cfg0 from port group dvsi0 to this pad." }
                      { value: "5", name: "port_dvsi0_cfg1", desc: "Connect port cfg1 from port group dvsi0 to this pad." }
                      { value: "6", name: "port_dvsi0_cfg2", desc: "Connect port cfg2 from port group dvsi0 to this pad." }
                      { value: "7", name: "port_dvsi0_cfg3", desc: "Connect port cfg3 from port group dvsi0 to this pad." }
                      { value: "8", name: "port_dvsi0_cfg4", desc: "Connect port cfg4 from port group dvsi0 to this pad." }
                      { value: "9", name: "port_dvsi0_cfg5", desc: "Connect port cfg5 from port group dvsi0 to this pad." }
                      { value: "10", name: "port_dvsi0_cfg6", desc: "Connect port cfg6 from port group dvsi0 to this pad." }
                      { value: "11", name: "port_dvsi0_cfg7", desc: "Connect port cfg7 from port group dvsi0 to this pad." }
                      { value: "12", name: "port_dvsi0_off0", desc: "Connect port off0 from port group dvsi0 to this pad." }
                      { value: "13", name: "port_dvsi0_off1", desc: "Connect port off1 from port group dvsi0 to this pad." }
                      { value: "14", name: "port_dvsi0_off2", desc: "Connect port off2 from port group dvsi0 to this pad." }
                      { value: "15", name: "port_dvsi0_off3", desc: "Connect port off3 from port group dvsi0 to this pad." }
                      { value: "16", name: "port_dvsi0_on0", desc: "Connect port on0 from port group dvsi0 to this pad." }
                      { value: "17", name: "port_dvsi0_on1", desc: "Connect port on1 from port group dvsi0 to this pad." }
                      { value: "18", name: "port_dvsi0_on2", desc: "Connect port on2 from port group dvsi0 to this pad." }
                      { value: "19", name: "port_dvsi0_on3", desc: "Connect port on3 from port group dvsi0 to this pad." }
                      { value: "20", name: "port_dvsi0_sxy", desc: "Connect port sxy from port group dvsi0 to this pad." }
                      { value: "21", name: "port_dvsi0_xclk", desc: "Connect port xclk from port group dvsi0 to this pad." }
                      { value: "22", name: "port_dvsi0_xnrst", desc: "Connect port xnrst from port group dvsi0 to this pad." }
                      { value: "23", name: "port_dvsi0_xydata0", desc: "Connect port xydata0 from port group dvsi0 to this pad." }
                      { value: "24", name: "port_dvsi0_xydata1", desc: "Connect port xydata1 from port group dvsi0 to this pad." }
                      { value: "25", name: "port_dvsi0_xydata2", desc: "Connect port xydata2 from port group dvsi0 to this pad." }
                      { value: "26", name: "port_dvsi0_xydata3", desc: "Connect port xydata3 from port group dvsi0 to this pad." }
                      { value: "27", name: "port_dvsi0_xydata4", desc: "Connect port xydata4 from port group dvsi0 to this pad." }
                      { value: "28", name: "port_dvsi0_xydata5", desc: "Connect port xydata5 from port group dvsi0 to this pad." }
                      { value: "29", name: "port_dvsi0_xydata6", desc: "Connect port xydata6 from port group dvsi0 to this pad." }
                      { value: "30", name: "port_dvsi0_xydata7", desc: "Connect port xydata7 from port group dvsi0 to this pad." }
                      { value: "31", name: "port_dvsi0_yclk", desc: "Connect port yclk from port group dvsi0 to this pad." }
                      { value: "32", name: "port_dvsi0_ynrst", desc: "Connect port ynrst from port group dvsi0 to this pad." }
                      { value: "33", name: "port_gpio_a_gpio3", desc: "Connect port gpio3 from port group gpio_a to this pad." }
                      { value: "34", name: "port_i2c0_i2c_scl", desc: "Connect port i2c_scl from port group i2c0 to this pad." }
                      { value: "35", name: "port_i2c0_i2c_sda", desc: "Connect port i2c_sda from port group i2c0 to this pad." }
                      { value: "36", name: "port_i2c1_i2c_scl", desc: "Connect port i2c_scl from port group i2c1 to this pad." }
                      { value: "37", name: "port_i2c1_i2c_sda", desc: "Connect port i2c_sda from port group i2c1 to this pad." }
                      { value: "38", name: "port_i2c2_i2c_scl", desc: "Connect port i2c_scl from port group i2c2 to this pad." }
                      { value: "39", name: "port_i2c2_i2c_sda", desc: "Connect port i2c_sda from port group i2c2 to this pad." }
                      { value: "40", name: "port_i2c3_i2c_scl", desc: "Connect port i2c_scl from port group i2c3 to this pad." }
                      { value: "41", name: "port_i2c3_i2c_sda", desc: "Connect port i2c_sda from port group i2c3 to this pad." }
                      { value: "42", name: "port_uart0_rx", desc: "Connect port rx from port group uart0 to this pad." }
                      { value: "43", name: "port_uart0_tx", desc: "Connect port tx from port group uart0 to this pad." }
                      { value: "44", name: "port_uart1_rx", desc: "Connect port rx from port group uart1 to this pad." }
                      { value: "45", name: "port_uart1_tx", desc: "Connect port tx from port group uart1 to this pad." }
                  ]
              }
          ]
      }

      {
          name: PAD_GPIOA4_CFG
          desc: '''
            Pad signal configuration.
          '''
          swaccess: "rw"
          fields: [
            {
                bits: "0"
                name: chip2pad
                desc: '''
                     The signal that connects to the pads TX driver
                '''
                swaccess: "rw"
                hwaccess: "hro"
                resval: "0"
            },
            {
                bits: "2:1"
                name: drv
                desc: '''
                     Driving strength selector
                '''
                swaccess: "rw"
                hwaccess: "hro"
                resval: "3"
            },
            {
                bits: "3"
                name: pde
                desc: '''
                     Pull down resistor enable
                '''
                swaccess: "rw"
                hwaccess: "hro"
                resval: "0"
            },
            {
                bits: "4"
                name: pue
                desc: '''
                     Pull up resistor enable
                '''
                swaccess: "rw"
                hwaccess: "hro"
                resval: "0"
            },
            {
                bits: "5"
                name: rxe
                desc: '''
                     Active high RX driver enable 
                '''
                swaccess: "rw"
                hwaccess: "hro"
                resval: "1"
            },
            {
                bits: "6"
                name: slw
                desc: '''
                     
                '''
                swaccess: "rw"
                hwaccess: "hro"
                resval: "0"
            },
            {
                bits: "7"
                name: smt
                desc: '''
                     Schmit trigger enable
                '''
                swaccess: "rw"
                hwaccess: "hro"
                resval: "0"
            },
            {
                bits: "8"
                name: trie
                desc: '''
                      Active high tri-state enable (active low TX driver enable)
                '''
                swaccess: "rw"
                hwaccess: "hro"
                resval: "1"
            },
          ]
      }

       {
          name: PAD_GPIOA4_MUX_SEL
          desc: '''
              Pad signal port multiplex selection for pad pad_gpioa4. The programmed value defines which port
              is connected to the pad.
          '''
          swaccess: "rw"
          hwaccess: "hro"
          resval: 0
          fields: [
              {
                  name: sel
                  desc: "Port selection index for pad pad_gpioa4."
                  bits: "5:0"
                  enum: [
                      { value: "0", name: "register", desc: "Connects the Pad to the internal configuration register."}
                      { value: "1", name: "port_dvsi0_are", desc: "Connect port are from port group dvsi0 to this pad." }
                      { value: "2", name: "port_dvsi0_asa", desc: "Connect port asa from port group dvsi0 to this pad." }
                      { value: "3", name: "port_dvsi0_asy", desc: "Connect port asy from port group dvsi0 to this pad." }
                      { value: "4", name: "port_dvsi0_cfg0", desc: "Connect port cfg0 from port group dvsi0 to this pad." }
                      { value: "5", name: "port_dvsi0_cfg1", desc: "Connect port cfg1 from port group dvsi0 to this pad." }
                      { value: "6", name: "port_dvsi0_cfg2", desc: "Connect port cfg2 from port group dvsi0 to this pad." }
                      { value: "7", name: "port_dvsi0_cfg3", desc: "Connect port cfg3 from port group dvsi0 to this pad." }
                      { value: "8", name: "port_dvsi0_cfg4", desc: "Connect port cfg4 from port group dvsi0 to this pad." }
                      { value: "9", name: "port_dvsi0_cfg5", desc: "Connect port cfg5 from port group dvsi0 to this pad." }
                      { value: "10", name: "port_dvsi0_cfg6", desc: "Connect port cfg6 from port group dvsi0 to this pad." }
                      { value: "11", name: "port_dvsi0_cfg7", desc: "Connect port cfg7 from port group dvsi0 to this pad." }
                      { value: "12", name: "port_dvsi0_off0", desc: "Connect port off0 from port group dvsi0 to this pad." }
                      { value: "13", name: "port_dvsi0_off1", desc: "Connect port off1 from port group dvsi0 to this pad." }
                      { value: "14", name: "port_dvsi0_off2", desc: "Connect port off2 from port group dvsi0 to this pad." }
                      { value: "15", name: "port_dvsi0_off3", desc: "Connect port off3 from port group dvsi0 to this pad." }
                      { value: "16", name: "port_dvsi0_on0", desc: "Connect port on0 from port group dvsi0 to this pad." }
                      { value: "17", name: "port_dvsi0_on1", desc: "Connect port on1 from port group dvsi0 to this pad." }
                      { value: "18", name: "port_dvsi0_on2", desc: "Connect port on2 from port group dvsi0 to this pad." }
                      { value: "19", name: "port_dvsi0_on3", desc: "Connect port on3 from port group dvsi0 to this pad." }
                      { value: "20", name: "port_dvsi0_sxy", desc: "Connect port sxy from port group dvsi0 to this pad." }
                      { value: "21", name: "port_dvsi0_xclk", desc: "Connect port xclk from port group dvsi0 to this pad." }
                      { value: "22", name: "port_dvsi0_xnrst", desc: "Connect port xnrst from port group dvsi0 to this pad." }
                      { value: "23", name: "port_dvsi0_xydata0", desc: "Connect port xydata0 from port group dvsi0 to this pad." }
                      { value: "24", name: "port_dvsi0_xydata1", desc: "Connect port xydata1 from port group dvsi0 to this pad." }
                      { value: "25", name: "port_dvsi0_xydata2", desc: "Connect port xydata2 from port group dvsi0 to this pad." }
                      { value: "26", name: "port_dvsi0_xydata3", desc: "Connect port xydata3 from port group dvsi0 to this pad." }
                      { value: "27", name: "port_dvsi0_xydata4", desc: "Connect port xydata4 from port group dvsi0 to this pad." }
                      { value: "28", name: "port_dvsi0_xydata5", desc: "Connect port xydata5 from port group dvsi0 to this pad." }
                      { value: "29", name: "port_dvsi0_xydata6", desc: "Connect port xydata6 from port group dvsi0 to this pad." }
                      { value: "30", name: "port_dvsi0_xydata7", desc: "Connect port xydata7 from port group dvsi0 to this pad." }
                      { value: "31", name: "port_dvsi0_yclk", desc: "Connect port yclk from port group dvsi0 to this pad." }
                      { value: "32", name: "port_dvsi0_ynrst", desc: "Connect port ynrst from port group dvsi0 to this pad." }
                      { value: "33", name: "port_gpio_a_gpio4", desc: "Connect port gpio4 from port group gpio_a to this pad." }
                      { value: "34", name: "port_i2c0_i2c_scl", desc: "Connect port i2c_scl from port group i2c0 to this pad." }
                      { value: "35", name: "port_i2c0_i2c_sda", desc: "Connect port i2c_sda from port group i2c0 to this pad." }
                      { value: "36", name: "port_i2c1_i2c_scl", desc: "Connect port i2c_scl from port group i2c1 to this pad." }
                      { value: "37", name: "port_i2c1_i2c_sda", desc: "Connect port i2c_sda from port group i2c1 to this pad." }
                      { value: "38", name: "port_i2c2_i2c_scl", desc: "Connect port i2c_scl from port group i2c2 to this pad." }
                      { value: "39", name: "port_i2c2_i2c_sda", desc: "Connect port i2c_sda from port group i2c2 to this pad." }
                      { value: "40", name: "port_i2c3_i2c_scl", desc: "Connect port i2c_scl from port group i2c3 to this pad." }
                      { value: "41", name: "port_i2c3_i2c_sda", desc: "Connect port i2c_sda from port group i2c3 to this pad." }
                      { value: "42", name: "port_uart0_rx", desc: "Connect port rx from port group uart0 to this pad." }
                      { value: "43", name: "port_uart0_tx", desc: "Connect port tx from port group uart0 to this pad." }
                      { value: "44", name: "port_uart1_rx", desc: "Connect port rx from port group uart1 to this pad." }
                      { value: "45", name: "port_uart1_tx", desc: "Connect port tx from port group uart1 to this pad." }
                  ]
              }
          ]
      }

      {
          name: PAD_GPIOA5_CFG
          desc: '''
            Pad signal configuration.
          '''
          swaccess: "rw"
          fields: [
            {
                bits: "0"
                name: chip2pad
                desc: '''
                     The signal that connects to the pads TX driver
                '''
                swaccess: "rw"
                hwaccess: "hro"
                resval: "0"
            },
            {
                bits: "2:1"
                name: drv
                desc: '''
                     Driving strength selector
                '''
                swaccess: "rw"
                hwaccess: "hro"
                resval: "3"
            },
            {
                bits: "3"
                name: pde
                desc: '''
                     Pull down resistor enable
                '''
                swaccess: "rw"
                hwaccess: "hro"
                resval: "0"
            },
            {
                bits: "4"
                name: pue
                desc: '''
                     Pull up resistor enable
                '''
                swaccess: "rw"
                hwaccess: "hro"
                resval: "0"
            },
            {
                bits: "5"
                name: rxe
                desc: '''
                     Active high RX driver enable 
                '''
                swaccess: "rw"
                hwaccess: "hro"
                resval: "1"
            },
            {
                bits: "6"
                name: slw
                desc: '''
                     
                '''
                swaccess: "rw"
                hwaccess: "hro"
                resval: "0"
            },
            {
                bits: "7"
                name: smt
                desc: '''
                     Schmit trigger enable
                '''
                swaccess: "rw"
                hwaccess: "hro"
                resval: "0"
            },
            {
                bits: "8"
                name: trie
                desc: '''
                      Active high tri-state enable (active low TX driver enable)
                '''
                swaccess: "rw"
                hwaccess: "hro"
                resval: "1"
            },
          ]
      }

       {
          name: PAD_GPIOA5_MUX_SEL
          desc: '''
              Pad signal port multiplex selection for pad pad_gpioa5. The programmed value defines which port
              is connected to the pad.
          '''
          swaccess: "rw"
          hwaccess: "hro"
          resval: 0
          fields: [
              {
                  name: sel
                  desc: "Port selection index for pad pad_gpioa5."
                  bits: "5:0"
                  enum: [
                      { value: "0", name: "register", desc: "Connects the Pad to the internal configuration register."}
                      { value: "1", name: "port_dvsi0_are", desc: "Connect port are from port group dvsi0 to this pad." }
                      { value: "2", name: "port_dvsi0_asa", desc: "Connect port asa from port group dvsi0 to this pad." }
                      { value: "3", name: "port_dvsi0_asy", desc: "Connect port asy from port group dvsi0 to this pad." }
                      { value: "4", name: "port_dvsi0_cfg0", desc: "Connect port cfg0 from port group dvsi0 to this pad." }
                      { value: "5", name: "port_dvsi0_cfg1", desc: "Connect port cfg1 from port group dvsi0 to this pad." }
                      { value: "6", name: "port_dvsi0_cfg2", desc: "Connect port cfg2 from port group dvsi0 to this pad." }
                      { value: "7", name: "port_dvsi0_cfg3", desc: "Connect port cfg3 from port group dvsi0 to this pad." }
                      { value: "8", name: "port_dvsi0_cfg4", desc: "Connect port cfg4 from port group dvsi0 to this pad." }
                      { value: "9", name: "port_dvsi0_cfg5", desc: "Connect port cfg5 from port group dvsi0 to this pad." }
                      { value: "10", name: "port_dvsi0_cfg6", desc: "Connect port cfg6 from port group dvsi0 to this pad." }
                      { value: "11", name: "port_dvsi0_cfg7", desc: "Connect port cfg7 from port group dvsi0 to this pad." }
                      { value: "12", name: "port_dvsi0_off0", desc: "Connect port off0 from port group dvsi0 to this pad." }
                      { value: "13", name: "port_dvsi0_off1", desc: "Connect port off1 from port group dvsi0 to this pad." }
                      { value: "14", name: "port_dvsi0_off2", desc: "Connect port off2 from port group dvsi0 to this pad." }
                      { value: "15", name: "port_dvsi0_off3", desc: "Connect port off3 from port group dvsi0 to this pad." }
                      { value: "16", name: "port_dvsi0_on0", desc: "Connect port on0 from port group dvsi0 to this pad." }
                      { value: "17", name: "port_dvsi0_on1", desc: "Connect port on1 from port group dvsi0 to this pad." }
                      { value: "18", name: "port_dvsi0_on2", desc: "Connect port on2 from port group dvsi0 to this pad." }
                      { value: "19", name: "port_dvsi0_on3", desc: "Connect port on3 from port group dvsi0 to this pad." }
                      { value: "20", name: "port_dvsi0_sxy", desc: "Connect port sxy from port group dvsi0 to this pad." }
                      { value: "21", name: "port_dvsi0_xclk", desc: "Connect port xclk from port group dvsi0 to this pad." }
                      { value: "22", name: "port_dvsi0_xnrst", desc: "Connect port xnrst from port group dvsi0 to this pad." }
                      { value: "23", name: "port_dvsi0_xydata0", desc: "Connect port xydata0 from port group dvsi0 to this pad." }
                      { value: "24", name: "port_dvsi0_xydata1", desc: "Connect port xydata1 from port group dvsi0 to this pad." }
                      { value: "25", name: "port_dvsi0_xydata2", desc: "Connect port xydata2 from port group dvsi0 to this pad." }
                      { value: "26", name: "port_dvsi0_xydata3", desc: "Connect port xydata3 from port group dvsi0 to this pad." }
                      { value: "27", name: "port_dvsi0_xydata4", desc: "Connect port xydata4 from port group dvsi0 to this pad." }
                      { value: "28", name: "port_dvsi0_xydata5", desc: "Connect port xydata5 from port group dvsi0 to this pad." }
                      { value: "29", name: "port_dvsi0_xydata6", desc: "Connect port xydata6 from port group dvsi0 to this pad." }
                      { value: "30", name: "port_dvsi0_xydata7", desc: "Connect port xydata7 from port group dvsi0 to this pad." }
                      { value: "31", name: "port_dvsi0_yclk", desc: "Connect port yclk from port group dvsi0 to this pad." }
                      { value: "32", name: "port_dvsi0_ynrst", desc: "Connect port ynrst from port group dvsi0 to this pad." }
                      { value: "33", name: "port_gpio_a_gpio5", desc: "Connect port gpio5 from port group gpio_a to this pad." }
                      { value: "34", name: "port_i2c0_i2c_scl", desc: "Connect port i2c_scl from port group i2c0 to this pad." }
                      { value: "35", name: "port_i2c0_i2c_sda", desc: "Connect port i2c_sda from port group i2c0 to this pad." }
                      { value: "36", name: "port_i2c1_i2c_scl", desc: "Connect port i2c_scl from port group i2c1 to this pad." }
                      { value: "37", name: "port_i2c1_i2c_sda", desc: "Connect port i2c_sda from port group i2c1 to this pad." }
                      { value: "38", name: "port_i2c2_i2c_scl", desc: "Connect port i2c_scl from port group i2c2 to this pad." }
                      { value: "39", name: "port_i2c2_i2c_sda", desc: "Connect port i2c_sda from port group i2c2 to this pad." }
                      { value: "40", name: "port_i2c3_i2c_scl", desc: "Connect port i2c_scl from port group i2c3 to this pad." }
                      { value: "41", name: "port_i2c3_i2c_sda", desc: "Connect port i2c_sda from port group i2c3 to this pad." }
                      { value: "42", name: "port_uart0_rx", desc: "Connect port rx from port group uart0 to this pad." }
                      { value: "43", name: "port_uart0_tx", desc: "Connect port tx from port group uart0 to this pad." }
                      { value: "44", name: "port_uart1_rx", desc: "Connect port rx from port group uart1 to this pad." }
                      { value: "45", name: "port_uart1_tx", desc: "Connect port tx from port group uart1 to this pad." }
                  ]
              }
          ]
      }

      {
          name: PAD_GPIOA6_CFG
          desc: '''
            Pad signal configuration.
          '''
          swaccess: "rw"
          fields: [
            {
                bits: "0"
                name: chip2pad
                desc: '''
                     The signal that connects to the pads TX driver
                '''
                swaccess: "rw"
                hwaccess: "hro"
                resval: "0"
            },
            {
                bits: "2:1"
                name: drv
                desc: '''
                     Driving strength selector
                '''
                swaccess: "rw"
                hwaccess: "hro"
                resval: "3"
            },
            {
                bits: "3"
                name: pde
                desc: '''
                     Pull down resistor enable
                '''
                swaccess: "rw"
                hwaccess: "hro"
                resval: "0"
            },
            {
                bits: "4"
                name: pue
                desc: '''
                     Pull up resistor enable
                '''
                swaccess: "rw"
                hwaccess: "hro"
                resval: "0"
            },
            {
                bits: "5"
                name: rxe
                desc: '''
                     Active high RX driver enable 
                '''
                swaccess: "rw"
                hwaccess: "hro"
                resval: "1"
            },
            {
                bits: "6"
                name: slw
                desc: '''
                     
                '''
                swaccess: "rw"
                hwaccess: "hro"
                resval: "0"
            },
            {
                bits: "7"
                name: smt
                desc: '''
                     Schmit trigger enable
                '''
                swaccess: "rw"
                hwaccess: "hro"
                resval: "0"
            },
            {
                bits: "8"
                name: trie
                desc: '''
                      Active high tri-state enable (active low TX driver enable)
                '''
                swaccess: "rw"
                hwaccess: "hro"
                resval: "1"
            },
          ]
      }

       {
          name: PAD_GPIOA6_MUX_SEL
          desc: '''
              Pad signal port multiplex selection for pad pad_gpioa6. The programmed value defines which port
              is connected to the pad.
          '''
          swaccess: "rw"
          hwaccess: "hro"
          resval: 0
          fields: [
              {
                  name: sel
                  desc: "Port selection index for pad pad_gpioa6."
                  bits: "5:0"
                  enum: [
                      { value: "0", name: "register", desc: "Connects the Pad to the internal configuration register."}
                      { value: "1", name: "port_dvsi0_are", desc: "Connect port are from port group dvsi0 to this pad." }
                      { value: "2", name: "port_dvsi0_asa", desc: "Connect port asa from port group dvsi0 to this pad." }
                      { value: "3", name: "port_dvsi0_asy", desc: "Connect port asy from port group dvsi0 to this pad." }
                      { value: "4", name: "port_dvsi0_cfg0", desc: "Connect port cfg0 from port group dvsi0 to this pad." }
                      { value: "5", name: "port_dvsi0_cfg1", desc: "Connect port cfg1 from port group dvsi0 to this pad." }
                      { value: "6", name: "port_dvsi0_cfg2", desc: "Connect port cfg2 from port group dvsi0 to this pad." }
                      { value: "7", name: "port_dvsi0_cfg3", desc: "Connect port cfg3 from port group dvsi0 to this pad." }
                      { value: "8", name: "port_dvsi0_cfg4", desc: "Connect port cfg4 from port group dvsi0 to this pad." }
                      { value: "9", name: "port_dvsi0_cfg5", desc: "Connect port cfg5 from port group dvsi0 to this pad." }
                      { value: "10", name: "port_dvsi0_cfg6", desc: "Connect port cfg6 from port group dvsi0 to this pad." }
                      { value: "11", name: "port_dvsi0_cfg7", desc: "Connect port cfg7 from port group dvsi0 to this pad." }
                      { value: "12", name: "port_dvsi0_off0", desc: "Connect port off0 from port group dvsi0 to this pad." }
                      { value: "13", name: "port_dvsi0_off1", desc: "Connect port off1 from port group dvsi0 to this pad." }
                      { value: "14", name: "port_dvsi0_off2", desc: "Connect port off2 from port group dvsi0 to this pad." }
                      { value: "15", name: "port_dvsi0_off3", desc: "Connect port off3 from port group dvsi0 to this pad." }
                      { value: "16", name: "port_dvsi0_on0", desc: "Connect port on0 from port group dvsi0 to this pad." }
                      { value: "17", name: "port_dvsi0_on1", desc: "Connect port on1 from port group dvsi0 to this pad." }
                      { value: "18", name: "port_dvsi0_on2", desc: "Connect port on2 from port group dvsi0 to this pad." }
                      { value: "19", name: "port_dvsi0_on3", desc: "Connect port on3 from port group dvsi0 to this pad." }
                      { value: "20", name: "port_dvsi0_sxy", desc: "Connect port sxy from port group dvsi0 to this pad." }
                      { value: "21", name: "port_dvsi0_xclk", desc: "Connect port xclk from port group dvsi0 to this pad." }
                      { value: "22", name: "port_dvsi0_xnrst", desc: "Connect port xnrst from port group dvsi0 to this pad." }
                      { value: "23", name: "port_dvsi0_xydata0", desc: "Connect port xydata0 from port group dvsi0 to this pad." }
                      { value: "24", name: "port_dvsi0_xydata1", desc: "Connect port xydata1 from port group dvsi0 to this pad." }
                      { value: "25", name: "port_dvsi0_xydata2", desc: "Connect port xydata2 from port group dvsi0 to this pad." }
                      { value: "26", name: "port_dvsi0_xydata3", desc: "Connect port xydata3 from port group dvsi0 to this pad." }
                      { value: "27", name: "port_dvsi0_xydata4", desc: "Connect port xydata4 from port group dvsi0 to this pad." }
                      { value: "28", name: "port_dvsi0_xydata5", desc: "Connect port xydata5 from port group dvsi0 to this pad." }
                      { value: "29", name: "port_dvsi0_xydata6", desc: "Connect port xydata6 from port group dvsi0 to this pad." }
                      { value: "30", name: "port_dvsi0_xydata7", desc: "Connect port xydata7 from port group dvsi0 to this pad." }
                      { value: "31", name: "port_dvsi0_yclk", desc: "Connect port yclk from port group dvsi0 to this pad." }
                      { value: "32", name: "port_dvsi0_ynrst", desc: "Connect port ynrst from port group dvsi0 to this pad." }
                      { value: "33", name: "port_gpio_a_gpio6", desc: "Connect port gpio6 from port group gpio_a to this pad." }
                      { value: "34", name: "port_i2c0_i2c_scl", desc: "Connect port i2c_scl from port group i2c0 to this pad." }
                      { value: "35", name: "port_i2c0_i2c_sda", desc: "Connect port i2c_sda from port group i2c0 to this pad." }
                      { value: "36", name: "port_i2c1_i2c_scl", desc: "Connect port i2c_scl from port group i2c1 to this pad." }
                      { value: "37", name: "port_i2c1_i2c_sda", desc: "Connect port i2c_sda from port group i2c1 to this pad." }
                      { value: "38", name: "port_i2c2_i2c_scl", desc: "Connect port i2c_scl from port group i2c2 to this pad." }
                      { value: "39", name: "port_i2c2_i2c_sda", desc: "Connect port i2c_sda from port group i2c2 to this pad." }
                      { value: "40", name: "port_i2c3_i2c_scl", desc: "Connect port i2c_scl from port group i2c3 to this pad." }
                      { value: "41", name: "port_i2c3_i2c_sda", desc: "Connect port i2c_sda from port group i2c3 to this pad." }
                      { value: "42", name: "port_uart0_rx", desc: "Connect port rx from port group uart0 to this pad." }
                      { value: "43", name: "port_uart0_tx", desc: "Connect port tx from port group uart0 to this pad." }
                      { value: "44", name: "port_uart1_rx", desc: "Connect port rx from port group uart1 to this pad." }
                      { value: "45", name: "port_uart1_tx", desc: "Connect port tx from port group uart1 to this pad." }
                  ]
              }
          ]
      }

      {
          name: PAD_GPIOA7_CFG
          desc: '''
            Pad signal configuration.
          '''
          swaccess: "rw"
          fields: [
            {
                bits: "0"
                name: chip2pad
                desc: '''
                     The signal that connects to the pads TX driver
                '''
                swaccess: "rw"
                hwaccess: "hro"
                resval: "0"
            },
            {
                bits: "2:1"
                name: drv
                desc: '''
                     Driving strength selector
                '''
                swaccess: "rw"
                hwaccess: "hro"
                resval: "3"
            },
            {
                bits: "3"
                name: pde
                desc: '''
                     Pull down resistor enable
                '''
                swaccess: "rw"
                hwaccess: "hro"
                resval: "0"
            },
            {
                bits: "4"
                name: pue
                desc: '''
                     Pull up resistor enable
                '''
                swaccess: "rw"
                hwaccess: "hro"
                resval: "0"
            },
            {
                bits: "5"
                name: rxe
                desc: '''
                     Active high RX driver enable 
                '''
                swaccess: "rw"
                hwaccess: "hro"
                resval: "1"
            },
            {
                bits: "6"
                name: slw
                desc: '''
                     
                '''
                swaccess: "rw"
                hwaccess: "hro"
                resval: "0"
            },
            {
                bits: "7"
                name: smt
                desc: '''
                     Schmit trigger enable
                '''
                swaccess: "rw"
                hwaccess: "hro"
                resval: "0"
            },
            {
                bits: "8"
                name: trie
                desc: '''
                      Active high tri-state enable (active low TX driver enable)
                '''
                swaccess: "rw"
                hwaccess: "hro"
                resval: "1"
            },
          ]
      }

       {
          name: PAD_GPIOA7_MUX_SEL
          desc: '''
              Pad signal port multiplex selection for pad pad_gpioa7. The programmed value defines which port
              is connected to the pad.
          '''
          swaccess: "rw"
          hwaccess: "hro"
          resval: 0
          fields: [
              {
                  name: sel
                  desc: "Port selection index for pad pad_gpioa7."
                  bits: "5:0"
                  enum: [
                      { value: "0", name: "register", desc: "Connects the Pad to the internal configuration register."}
                      { value: "1", name: "port_dvsi0_are", desc: "Connect port are from port group dvsi0 to this pad." }
                      { value: "2", name: "port_dvsi0_asa", desc: "Connect port asa from port group dvsi0 to this pad." }
                      { value: "3", name: "port_dvsi0_asy", desc: "Connect port asy from port group dvsi0 to this pad." }
                      { value: "4", name: "port_dvsi0_cfg0", desc: "Connect port cfg0 from port group dvsi0 to this pad." }
                      { value: "5", name: "port_dvsi0_cfg1", desc: "Connect port cfg1 from port group dvsi0 to this pad." }
                      { value: "6", name: "port_dvsi0_cfg2", desc: "Connect port cfg2 from port group dvsi0 to this pad." }
                      { value: "7", name: "port_dvsi0_cfg3", desc: "Connect port cfg3 from port group dvsi0 to this pad." }
                      { value: "8", name: "port_dvsi0_cfg4", desc: "Connect port cfg4 from port group dvsi0 to this pad." }
                      { value: "9", name: "port_dvsi0_cfg5", desc: "Connect port cfg5 from port group dvsi0 to this pad." }
                      { value: "10", name: "port_dvsi0_cfg6", desc: "Connect port cfg6 from port group dvsi0 to this pad." }
                      { value: "11", name: "port_dvsi0_cfg7", desc: "Connect port cfg7 from port group dvsi0 to this pad." }
                      { value: "12", name: "port_dvsi0_off0", desc: "Connect port off0 from port group dvsi0 to this pad." }
                      { value: "13", name: "port_dvsi0_off1", desc: "Connect port off1 from port group dvsi0 to this pad." }
                      { value: "14", name: "port_dvsi0_off2", desc: "Connect port off2 from port group dvsi0 to this pad." }
                      { value: "15", name: "port_dvsi0_off3", desc: "Connect port off3 from port group dvsi0 to this pad." }
                      { value: "16", name: "port_dvsi0_on0", desc: "Connect port on0 from port group dvsi0 to this pad." }
                      { value: "17", name: "port_dvsi0_on1", desc: "Connect port on1 from port group dvsi0 to this pad." }
                      { value: "18", name: "port_dvsi0_on2", desc: "Connect port on2 from port group dvsi0 to this pad." }
                      { value: "19", name: "port_dvsi0_on3", desc: "Connect port on3 from port group dvsi0 to this pad." }
                      { value: "20", name: "port_dvsi0_sxy", desc: "Connect port sxy from port group dvsi0 to this pad." }
                      { value: "21", name: "port_dvsi0_xclk", desc: "Connect port xclk from port group dvsi0 to this pad." }
                      { value: "22", name: "port_dvsi0_xnrst", desc: "Connect port xnrst from port group dvsi0 to this pad." }
                      { value: "23", name: "port_dvsi0_xydata0", desc: "Connect port xydata0 from port group dvsi0 to this pad." }
                      { value: "24", name: "port_dvsi0_xydata1", desc: "Connect port xydata1 from port group dvsi0 to this pad." }
                      { value: "25", name: "port_dvsi0_xydata2", desc: "Connect port xydata2 from port group dvsi0 to this pad." }
                      { value: "26", name: "port_dvsi0_xydata3", desc: "Connect port xydata3 from port group dvsi0 to this pad." }
                      { value: "27", name: "port_dvsi0_xydata4", desc: "Connect port xydata4 from port group dvsi0 to this pad." }
                      { value: "28", name: "port_dvsi0_xydata5", desc: "Connect port xydata5 from port group dvsi0 to this pad." }
                      { value: "29", name: "port_dvsi0_xydata6", desc: "Connect port xydata6 from port group dvsi0 to this pad." }
                      { value: "30", name: "port_dvsi0_xydata7", desc: "Connect port xydata7 from port group dvsi0 to this pad." }
                      { value: "31", name: "port_dvsi0_yclk", desc: "Connect port yclk from port group dvsi0 to this pad." }
                      { value: "32", name: "port_dvsi0_ynrst", desc: "Connect port ynrst from port group dvsi0 to this pad." }
                      { value: "33", name: "port_gpio_a_gpio7", desc: "Connect port gpio7 from port group gpio_a to this pad." }
                      { value: "34", name: "port_i2c0_i2c_scl", desc: "Connect port i2c_scl from port group i2c0 to this pad." }
                      { value: "35", name: "port_i2c0_i2c_sda", desc: "Connect port i2c_sda from port group i2c0 to this pad." }
                      { value: "36", name: "port_i2c1_i2c_scl", desc: "Connect port i2c_scl from port group i2c1 to this pad." }
                      { value: "37", name: "port_i2c1_i2c_sda", desc: "Connect port i2c_sda from port group i2c1 to this pad." }
                      { value: "38", name: "port_i2c2_i2c_scl", desc: "Connect port i2c_scl from port group i2c2 to this pad." }
                      { value: "39", name: "port_i2c2_i2c_sda", desc: "Connect port i2c_sda from port group i2c2 to this pad." }
                      { value: "40", name: "port_i2c3_i2c_scl", desc: "Connect port i2c_scl from port group i2c3 to this pad." }
                      { value: "41", name: "port_i2c3_i2c_sda", desc: "Connect port i2c_sda from port group i2c3 to this pad." }
                      { value: "42", name: "port_uart0_rx", desc: "Connect port rx from port group uart0 to this pad." }
                      { value: "43", name: "port_uart0_tx", desc: "Connect port tx from port group uart0 to this pad." }
                      { value: "44", name: "port_uart1_rx", desc: "Connect port rx from port group uart1 to this pad." }
                      { value: "45", name: "port_uart1_tx", desc: "Connect port tx from port group uart1 to this pad." }
                  ]
              }
          ]
      }

      {
          name: PAD_GPIOA8_CFG
          desc: '''
            Pad signal configuration.
          '''
          swaccess: "rw"
          fields: [
            {
                bits: "0"
                name: chip2pad
                desc: '''
                     The signal that connects to the pads TX driver
                '''
                swaccess: "rw"
                hwaccess: "hro"
                resval: "0"
            },
            {
                bits: "2:1"
                name: drv
                desc: '''
                     Driving strength selector
                '''
                swaccess: "rw"
                hwaccess: "hro"
                resval: "3"
            },
            {
                bits: "3"
                name: pde
                desc: '''
                     Pull down resistor enable
                '''
                swaccess: "rw"
                hwaccess: "hro"
                resval: "0"
            },
            {
                bits: "4"
                name: pue
                desc: '''
                     Pull up resistor enable
                '''
                swaccess: "rw"
                hwaccess: "hro"
                resval: "0"
            },
            {
                bits: "5"
                name: rxe
                desc: '''
                     Active high RX driver enable 
                '''
                swaccess: "rw"
                hwaccess: "hro"
                resval: "1"
            },
            {
                bits: "6"
                name: slw
                desc: '''
                     
                '''
                swaccess: "rw"
                hwaccess: "hro"
                resval: "0"
            },
            {
                bits: "7"
                name: smt
                desc: '''
                     Schmit trigger enable
                '''
                swaccess: "rw"
                hwaccess: "hro"
                resval: "0"
            },
            {
                bits: "8"
                name: trie
                desc: '''
                      Active high tri-state enable (active low TX driver enable)
                '''
                swaccess: "rw"
                hwaccess: "hro"
                resval: "1"
            },
          ]
      }

       {
          name: PAD_GPIOA8_MUX_SEL
          desc: '''
              Pad signal port multiplex selection for pad pad_gpioa8. The programmed value defines which port
              is connected to the pad.
          '''
          swaccess: "rw"
          hwaccess: "hro"
          resval: 0
          fields: [
              {
                  name: sel
                  desc: "Port selection index for pad pad_gpioa8."
                  bits: "5:0"
                  enum: [
                      { value: "0", name: "register", desc: "Connects the Pad to the internal configuration register."}
                      { value: "1", name: "port_dvsi0_are", desc: "Connect port are from port group dvsi0 to this pad." }
                      { value: "2", name: "port_dvsi0_asa", desc: "Connect port asa from port group dvsi0 to this pad." }
                      { value: "3", name: "port_dvsi0_asy", desc: "Connect port asy from port group dvsi0 to this pad." }
                      { value: "4", name: "port_dvsi0_cfg0", desc: "Connect port cfg0 from port group dvsi0 to this pad." }
                      { value: "5", name: "port_dvsi0_cfg1", desc: "Connect port cfg1 from port group dvsi0 to this pad." }
                      { value: "6", name: "port_dvsi0_cfg2", desc: "Connect port cfg2 from port group dvsi0 to this pad." }
                      { value: "7", name: "port_dvsi0_cfg3", desc: "Connect port cfg3 from port group dvsi0 to this pad." }
                      { value: "8", name: "port_dvsi0_cfg4", desc: "Connect port cfg4 from port group dvsi0 to this pad." }
                      { value: "9", name: "port_dvsi0_cfg5", desc: "Connect port cfg5 from port group dvsi0 to this pad." }
                      { value: "10", name: "port_dvsi0_cfg6", desc: "Connect port cfg6 from port group dvsi0 to this pad." }
                      { value: "11", name: "port_dvsi0_cfg7", desc: "Connect port cfg7 from port group dvsi0 to this pad." }
                      { value: "12", name: "port_dvsi0_off0", desc: "Connect port off0 from port group dvsi0 to this pad." }
                      { value: "13", name: "port_dvsi0_off1", desc: "Connect port off1 from port group dvsi0 to this pad." }
                      { value: "14", name: "port_dvsi0_off2", desc: "Connect port off2 from port group dvsi0 to this pad." }
                      { value: "15", name: "port_dvsi0_off3", desc: "Connect port off3 from port group dvsi0 to this pad." }
                      { value: "16", name: "port_dvsi0_on0", desc: "Connect port on0 from port group dvsi0 to this pad." }
                      { value: "17", name: "port_dvsi0_on1", desc: "Connect port on1 from port group dvsi0 to this pad." }
                      { value: "18", name: "port_dvsi0_on2", desc: "Connect port on2 from port group dvsi0 to this pad." }
                      { value: "19", name: "port_dvsi0_on3", desc: "Connect port on3 from port group dvsi0 to this pad." }
                      { value: "20", name: "port_dvsi0_sxy", desc: "Connect port sxy from port group dvsi0 to this pad." }
                      { value: "21", name: "port_dvsi0_xclk", desc: "Connect port xclk from port group dvsi0 to this pad." }
                      { value: "22", name: "port_dvsi0_xnrst", desc: "Connect port xnrst from port group dvsi0 to this pad." }
                      { value: "23", name: "port_dvsi0_xydata0", desc: "Connect port xydata0 from port group dvsi0 to this pad." }
                      { value: "24", name: "port_dvsi0_xydata1", desc: "Connect port xydata1 from port group dvsi0 to this pad." }
                      { value: "25", name: "port_dvsi0_xydata2", desc: "Connect port xydata2 from port group dvsi0 to this pad." }
                      { value: "26", name: "port_dvsi0_xydata3", desc: "Connect port xydata3 from port group dvsi0 to this pad." }
                      { value: "27", name: "port_dvsi0_xydata4", desc: "Connect port xydata4 from port group dvsi0 to this pad." }
                      { value: "28", name: "port_dvsi0_xydata5", desc: "Connect port xydata5 from port group dvsi0 to this pad." }
                      { value: "29", name: "port_dvsi0_xydata6", desc: "Connect port xydata6 from port group dvsi0 to this pad." }
                      { value: "30", name: "port_dvsi0_xydata7", desc: "Connect port xydata7 from port group dvsi0 to this pad." }
                      { value: "31", name: "port_dvsi0_yclk", desc: "Connect port yclk from port group dvsi0 to this pad." }
                      { value: "32", name: "port_dvsi0_ynrst", desc: "Connect port ynrst from port group dvsi0 to this pad." }
                      { value: "33", name: "port_gpio_a_gpio8", desc: "Connect port gpio8 from port group gpio_a to this pad." }
                      { value: "34", name: "port_i2c0_i2c_scl", desc: "Connect port i2c_scl from port group i2c0 to this pad." }
                      { value: "35", name: "port_i2c0_i2c_sda", desc: "Connect port i2c_sda from port group i2c0 to this pad." }
                      { value: "36", name: "port_i2c1_i2c_scl", desc: "Connect port i2c_scl from port group i2c1 to this pad." }
                      { value: "37", name: "port_i2c1_i2c_sda", desc: "Connect port i2c_sda from port group i2c1 to this pad." }
                      { value: "38", name: "port_i2c2_i2c_scl", desc: "Connect port i2c_scl from port group i2c2 to this pad." }
                      { value: "39", name: "port_i2c2_i2c_sda", desc: "Connect port i2c_sda from port group i2c2 to this pad." }
                      { value: "40", name: "port_i2c3_i2c_scl", desc: "Connect port i2c_scl from port group i2c3 to this pad." }
                      { value: "41", name: "port_i2c3_i2c_sda", desc: "Connect port i2c_sda from port group i2c3 to this pad." }
                      { value: "42", name: "port_uart0_rx", desc: "Connect port rx from port group uart0 to this pad." }
                      { value: "43", name: "port_uart0_tx", desc: "Connect port tx from port group uart0 to this pad." }
                      { value: "44", name: "port_uart1_rx", desc: "Connect port rx from port group uart1 to this pad." }
                      { value: "45", name: "port_uart1_tx", desc: "Connect port tx from port group uart1 to this pad." }
                  ]
              }
          ]
      }

      {
          name: PAD_GPIOA9_CFG
          desc: '''
            Pad signal configuration.
          '''
          swaccess: "rw"
          fields: [
            {
                bits: "0"
                name: chip2pad
                desc: '''
                     The signal that connects to the pads TX driver
                '''
                swaccess: "rw"
                hwaccess: "hro"
                resval: "0"
            },
            {
                bits: "2:1"
                name: drv
                desc: '''
                     Driving strength selector
                '''
                swaccess: "rw"
                hwaccess: "hro"
                resval: "3"
            },
            {
                bits: "3"
                name: pde
                desc: '''
                     Pull down resistor enable
                '''
                swaccess: "rw"
                hwaccess: "hro"
                resval: "0"
            },
            {
                bits: "4"
                name: pue
                desc: '''
                     Pull up resistor enable
                '''
                swaccess: "rw"
                hwaccess: "hro"
                resval: "0"
            },
            {
                bits: "5"
                name: rxe
                desc: '''
                     Active high RX driver enable 
                '''
                swaccess: "rw"
                hwaccess: "hro"
                resval: "1"
            },
            {
                bits: "6"
                name: slw
                desc: '''
                     
                '''
                swaccess: "rw"
                hwaccess: "hro"
                resval: "0"
            },
            {
                bits: "7"
                name: smt
                desc: '''
                     Schmit trigger enable
                '''
                swaccess: "rw"
                hwaccess: "hro"
                resval: "0"
            },
            {
                bits: "8"
                name: trie
                desc: '''
                      Active high tri-state enable (active low TX driver enable)
                '''
                swaccess: "rw"
                hwaccess: "hro"
                resval: "1"
            },
          ]
      }

       {
          name: PAD_GPIOA9_MUX_SEL
          desc: '''
              Pad signal port multiplex selection for pad pad_gpioa9. The programmed value defines which port
              is connected to the pad.
          '''
          swaccess: "rw"
          hwaccess: "hro"
          resval: 0
          fields: [
              {
                  name: sel
                  desc: "Port selection index for pad pad_gpioa9."
                  bits: "5:0"
                  enum: [
                      { value: "0", name: "register", desc: "Connects the Pad to the internal configuration register."}
                      { value: "1", name: "port_dvsi0_are", desc: "Connect port are from port group dvsi0 to this pad." }
                      { value: "2", name: "port_dvsi0_asa", desc: "Connect port asa from port group dvsi0 to this pad." }
                      { value: "3", name: "port_dvsi0_asy", desc: "Connect port asy from port group dvsi0 to this pad." }
                      { value: "4", name: "port_dvsi0_cfg0", desc: "Connect port cfg0 from port group dvsi0 to this pad." }
                      { value: "5", name: "port_dvsi0_cfg1", desc: "Connect port cfg1 from port group dvsi0 to this pad." }
                      { value: "6", name: "port_dvsi0_cfg2", desc: "Connect port cfg2 from port group dvsi0 to this pad." }
                      { value: "7", name: "port_dvsi0_cfg3", desc: "Connect port cfg3 from port group dvsi0 to this pad." }
                      { value: "8", name: "port_dvsi0_cfg4", desc: "Connect port cfg4 from port group dvsi0 to this pad." }
                      { value: "9", name: "port_dvsi0_cfg5", desc: "Connect port cfg5 from port group dvsi0 to this pad." }
                      { value: "10", name: "port_dvsi0_cfg6", desc: "Connect port cfg6 from port group dvsi0 to this pad." }
                      { value: "11", name: "port_dvsi0_cfg7", desc: "Connect port cfg7 from port group dvsi0 to this pad." }
                      { value: "12", name: "port_dvsi0_off0", desc: "Connect port off0 from port group dvsi0 to this pad." }
                      { value: "13", name: "port_dvsi0_off1", desc: "Connect port off1 from port group dvsi0 to this pad." }
                      { value: "14", name: "port_dvsi0_off2", desc: "Connect port off2 from port group dvsi0 to this pad." }
                      { value: "15", name: "port_dvsi0_off3", desc: "Connect port off3 from port group dvsi0 to this pad." }
                      { value: "16", name: "port_dvsi0_on0", desc: "Connect port on0 from port group dvsi0 to this pad." }
                      { value: "17", name: "port_dvsi0_on1", desc: "Connect port on1 from port group dvsi0 to this pad." }
                      { value: "18", name: "port_dvsi0_on2", desc: "Connect port on2 from port group dvsi0 to this pad." }
                      { value: "19", name: "port_dvsi0_on3", desc: "Connect port on3 from port group dvsi0 to this pad." }
                      { value: "20", name: "port_dvsi0_sxy", desc: "Connect port sxy from port group dvsi0 to this pad." }
                      { value: "21", name: "port_dvsi0_xclk", desc: "Connect port xclk from port group dvsi0 to this pad." }
                      { value: "22", name: "port_dvsi0_xnrst", desc: "Connect port xnrst from port group dvsi0 to this pad." }
                      { value: "23", name: "port_dvsi0_xydata0", desc: "Connect port xydata0 from port group dvsi0 to this pad." }
                      { value: "24", name: "port_dvsi0_xydata1", desc: "Connect port xydata1 from port group dvsi0 to this pad." }
                      { value: "25", name: "port_dvsi0_xydata2", desc: "Connect port xydata2 from port group dvsi0 to this pad." }
                      { value: "26", name: "port_dvsi0_xydata3", desc: "Connect port xydata3 from port group dvsi0 to this pad." }
                      { value: "27", name: "port_dvsi0_xydata4", desc: "Connect port xydata4 from port group dvsi0 to this pad." }
                      { value: "28", name: "port_dvsi0_xydata5", desc: "Connect port xydata5 from port group dvsi0 to this pad." }
                      { value: "29", name: "port_dvsi0_xydata6", desc: "Connect port xydata6 from port group dvsi0 to this pad." }
                      { value: "30", name: "port_dvsi0_xydata7", desc: "Connect port xydata7 from port group dvsi0 to this pad." }
                      { value: "31", name: "port_dvsi0_yclk", desc: "Connect port yclk from port group dvsi0 to this pad." }
                      { value: "32", name: "port_dvsi0_ynrst", desc: "Connect port ynrst from port group dvsi0 to this pad." }
                      { value: "33", name: "port_gpio_a_gpio9", desc: "Connect port gpio9 from port group gpio_a to this pad." }
                      { value: "34", name: "port_i2c0_i2c_scl", desc: "Connect port i2c_scl from port group i2c0 to this pad." }
                      { value: "35", name: "port_i2c0_i2c_sda", desc: "Connect port i2c_sda from port group i2c0 to this pad." }
                      { value: "36", name: "port_i2c1_i2c_scl", desc: "Connect port i2c_scl from port group i2c1 to this pad." }
                      { value: "37", name: "port_i2c1_i2c_sda", desc: "Connect port i2c_sda from port group i2c1 to this pad." }
                      { value: "38", name: "port_i2c2_i2c_scl", desc: "Connect port i2c_scl from port group i2c2 to this pad." }
                      { value: "39", name: "port_i2c2_i2c_sda", desc: "Connect port i2c_sda from port group i2c2 to this pad." }
                      { value: "40", name: "port_i2c3_i2c_scl", desc: "Connect port i2c_scl from port group i2c3 to this pad." }
                      { value: "41", name: "port_i2c3_i2c_sda", desc: "Connect port i2c_sda from port group i2c3 to this pad." }
                      { value: "42", name: "port_uart0_rx", desc: "Connect port rx from port group uart0 to this pad." }
                      { value: "43", name: "port_uart0_tx", desc: "Connect port tx from port group uart0 to this pad." }
                      { value: "44", name: "port_uart1_rx", desc: "Connect port rx from port group uart1 to this pad." }
                      { value: "45", name: "port_uart1_tx", desc: "Connect port tx from port group uart1 to this pad." }
                  ]
              }
          ]
      }

      {
          name: PAD_GPIOA10_CFG
          desc: '''
            Pad signal configuration.
          '''
          swaccess: "rw"
          fields: [
            {
                bits: "0"
                name: chip2pad
                desc: '''
                     The signal that connects to the pads TX driver
                '''
                swaccess: "rw"
                hwaccess: "hro"
                resval: "0"
            },
            {
                bits: "2:1"
                name: drv
                desc: '''
                     Driving strength selector
                '''
                swaccess: "rw"
                hwaccess: "hro"
                resval: "3"
            },
            {
                bits: "3"
                name: pde
                desc: '''
                     Pull down resistor enable
                '''
                swaccess: "rw"
                hwaccess: "hro"
                resval: "0"
            },
            {
                bits: "4"
                name: pue
                desc: '''
                     Pull up resistor enable
                '''
                swaccess: "rw"
                hwaccess: "hro"
                resval: "0"
            },
            {
                bits: "5"
                name: rxe
                desc: '''
                     Active high RX driver enable 
                '''
                swaccess: "rw"
                hwaccess: "hro"
                resval: "1"
            },
            {
                bits: "6"
                name: slw
                desc: '''
                     
                '''
                swaccess: "rw"
                hwaccess: "hro"
                resval: "0"
            },
            {
                bits: "7"
                name: smt
                desc: '''
                     Schmit trigger enable
                '''
                swaccess: "rw"
                hwaccess: "hro"
                resval: "0"
            },
            {
                bits: "8"
                name: trie
                desc: '''
                      Active high tri-state enable (active low TX driver enable)
                '''
                swaccess: "rw"
                hwaccess: "hro"
                resval: "1"
            },
          ]
      }

       {
          name: PAD_GPIOA10_MUX_SEL
          desc: '''
              Pad signal port multiplex selection for pad pad_gpioa10. The programmed value defines which port
              is connected to the pad.
          '''
          swaccess: "rw"
          hwaccess: "hro"
          resval: 0
          fields: [
              {
                  name: sel
                  desc: "Port selection index for pad pad_gpioa10."
                  bits: "5:0"
                  enum: [
                      { value: "0", name: "register", desc: "Connects the Pad to the internal configuration register."}
                      { value: "1", name: "port_dvsi0_are", desc: "Connect port are from port group dvsi0 to this pad." }
                      { value: "2", name: "port_dvsi0_asa", desc: "Connect port asa from port group dvsi0 to this pad." }
                      { value: "3", name: "port_dvsi0_asy", desc: "Connect port asy from port group dvsi0 to this pad." }
                      { value: "4", name: "port_dvsi0_cfg0", desc: "Connect port cfg0 from port group dvsi0 to this pad." }
                      { value: "5", name: "port_dvsi0_cfg1", desc: "Connect port cfg1 from port group dvsi0 to this pad." }
                      { value: "6", name: "port_dvsi0_cfg2", desc: "Connect port cfg2 from port group dvsi0 to this pad." }
                      { value: "7", name: "port_dvsi0_cfg3", desc: "Connect port cfg3 from port group dvsi0 to this pad." }
                      { value: "8", name: "port_dvsi0_cfg4", desc: "Connect port cfg4 from port group dvsi0 to this pad." }
                      { value: "9", name: "port_dvsi0_cfg5", desc: "Connect port cfg5 from port group dvsi0 to this pad." }
                      { value: "10", name: "port_dvsi0_cfg6", desc: "Connect port cfg6 from port group dvsi0 to this pad." }
                      { value: "11", name: "port_dvsi0_cfg7", desc: "Connect port cfg7 from port group dvsi0 to this pad." }
                      { value: "12", name: "port_dvsi0_off0", desc: "Connect port off0 from port group dvsi0 to this pad." }
                      { value: "13", name: "port_dvsi0_off1", desc: "Connect port off1 from port group dvsi0 to this pad." }
                      { value: "14", name: "port_dvsi0_off2", desc: "Connect port off2 from port group dvsi0 to this pad." }
                      { value: "15", name: "port_dvsi0_off3", desc: "Connect port off3 from port group dvsi0 to this pad." }
                      { value: "16", name: "port_dvsi0_on0", desc: "Connect port on0 from port group dvsi0 to this pad." }
                      { value: "17", name: "port_dvsi0_on1", desc: "Connect port on1 from port group dvsi0 to this pad." }
                      { value: "18", name: "port_dvsi0_on2", desc: "Connect port on2 from port group dvsi0 to this pad." }
                      { value: "19", name: "port_dvsi0_on3", desc: "Connect port on3 from port group dvsi0 to this pad." }
                      { value: "20", name: "port_dvsi0_sxy", desc: "Connect port sxy from port group dvsi0 to this pad." }
                      { value: "21", name: "port_dvsi0_xclk", desc: "Connect port xclk from port group dvsi0 to this pad." }
                      { value: "22", name: "port_dvsi0_xnrst", desc: "Connect port xnrst from port group dvsi0 to this pad." }
                      { value: "23", name: "port_dvsi0_xydata0", desc: "Connect port xydata0 from port group dvsi0 to this pad." }
                      { value: "24", name: "port_dvsi0_xydata1", desc: "Connect port xydata1 from port group dvsi0 to this pad." }
                      { value: "25", name: "port_dvsi0_xydata2", desc: "Connect port xydata2 from port group dvsi0 to this pad." }
                      { value: "26", name: "port_dvsi0_xydata3", desc: "Connect port xydata3 from port group dvsi0 to this pad." }
                      { value: "27", name: "port_dvsi0_xydata4", desc: "Connect port xydata4 from port group dvsi0 to this pad." }
                      { value: "28", name: "port_dvsi0_xydata5", desc: "Connect port xydata5 from port group dvsi0 to this pad." }
                      { value: "29", name: "port_dvsi0_xydata6", desc: "Connect port xydata6 from port group dvsi0 to this pad." }
                      { value: "30", name: "port_dvsi0_xydata7", desc: "Connect port xydata7 from port group dvsi0 to this pad." }
                      { value: "31", name: "port_dvsi0_yclk", desc: "Connect port yclk from port group dvsi0 to this pad." }
                      { value: "32", name: "port_dvsi0_ynrst", desc: "Connect port ynrst from port group dvsi0 to this pad." }
                      { value: "33", name: "port_gpio_a_gpio10", desc: "Connect port gpio10 from port group gpio_a to this pad." }
                      { value: "34", name: "port_i2c0_i2c_scl", desc: "Connect port i2c_scl from port group i2c0 to this pad." }
                      { value: "35", name: "port_i2c0_i2c_sda", desc: "Connect port i2c_sda from port group i2c0 to this pad." }
                      { value: "36", name: "port_i2c1_i2c_scl", desc: "Connect port i2c_scl from port group i2c1 to this pad." }
                      { value: "37", name: "port_i2c1_i2c_sda", desc: "Connect port i2c_sda from port group i2c1 to this pad." }
                      { value: "38", name: "port_i2c2_i2c_scl", desc: "Connect port i2c_scl from port group i2c2 to this pad." }
                      { value: "39", name: "port_i2c2_i2c_sda", desc: "Connect port i2c_sda from port group i2c2 to this pad." }
                      { value: "40", name: "port_i2c3_i2c_scl", desc: "Connect port i2c_scl from port group i2c3 to this pad." }
                      { value: "41", name: "port_i2c3_i2c_sda", desc: "Connect port i2c_sda from port group i2c3 to this pad." }
                      { value: "42", name: "port_uart0_rx", desc: "Connect port rx from port group uart0 to this pad." }
                      { value: "43", name: "port_uart0_tx", desc: "Connect port tx from port group uart0 to this pad." }
                      { value: "44", name: "port_uart1_rx", desc: "Connect port rx from port group uart1 to this pad." }
                      { value: "45", name: "port_uart1_tx", desc: "Connect port tx from port group uart1 to this pad." }
                  ]
              }
          ]
      }

      {
          name: PAD_GPIOA11_CFG
          desc: '''
            Pad signal configuration.
          '''
          swaccess: "rw"
          fields: [
            {
                bits: "0"
                name: chip2pad
                desc: '''
                     The signal that connects to the pads TX driver
                '''
                swaccess: "rw"
                hwaccess: "hro"
                resval: "0"
            },
            {
                bits: "2:1"
                name: drv
                desc: '''
                     Driving strength selector
                '''
                swaccess: "rw"
                hwaccess: "hro"
                resval: "3"
            },
            {
                bits: "3"
                name: pde
                desc: '''
                     Pull down resistor enable
                '''
                swaccess: "rw"
                hwaccess: "hro"
                resval: "0"
            },
            {
                bits: "4"
                name: pue
                desc: '''
                     Pull up resistor enable
                '''
                swaccess: "rw"
                hwaccess: "hro"
                resval: "0"
            },
            {
                bits: "5"
                name: rxe
                desc: '''
                     Active high RX driver enable 
                '''
                swaccess: "rw"
                hwaccess: "hro"
                resval: "1"
            },
            {
                bits: "6"
                name: slw
                desc: '''
                     
                '''
                swaccess: "rw"
                hwaccess: "hro"
                resval: "0"
            },
            {
                bits: "7"
                name: smt
                desc: '''
                     Schmit trigger enable
                '''
                swaccess: "rw"
                hwaccess: "hro"
                resval: "0"
            },
            {
                bits: "8"
                name: trie
                desc: '''
                      Active high tri-state enable (active low TX driver enable)
                '''
                swaccess: "rw"
                hwaccess: "hro"
                resval: "1"
            },
          ]
      }

       {
          name: PAD_GPIOA11_MUX_SEL
          desc: '''
              Pad signal port multiplex selection for pad pad_gpioa11. The programmed value defines which port
              is connected to the pad.
          '''
          swaccess: "rw"
          hwaccess: "hro"
          resval: 0
          fields: [
              {
                  name: sel
                  desc: "Port selection index for pad pad_gpioa11."
                  bits: "5:0"
                  enum: [
                      { value: "0", name: "register", desc: "Connects the Pad to the internal configuration register."}
                      { value: "1", name: "port_dvsi0_are", desc: "Connect port are from port group dvsi0 to this pad." }
                      { value: "2", name: "port_dvsi0_asa", desc: "Connect port asa from port group dvsi0 to this pad." }
                      { value: "3", name: "port_dvsi0_asy", desc: "Connect port asy from port group dvsi0 to this pad." }
                      { value: "4", name: "port_dvsi0_cfg0", desc: "Connect port cfg0 from port group dvsi0 to this pad." }
                      { value: "5", name: "port_dvsi0_cfg1", desc: "Connect port cfg1 from port group dvsi0 to this pad." }
                      { value: "6", name: "port_dvsi0_cfg2", desc: "Connect port cfg2 from port group dvsi0 to this pad." }
                      { value: "7", name: "port_dvsi0_cfg3", desc: "Connect port cfg3 from port group dvsi0 to this pad." }
                      { value: "8", name: "port_dvsi0_cfg4", desc: "Connect port cfg4 from port group dvsi0 to this pad." }
                      { value: "9", name: "port_dvsi0_cfg5", desc: "Connect port cfg5 from port group dvsi0 to this pad." }
                      { value: "10", name: "port_dvsi0_cfg6", desc: "Connect port cfg6 from port group dvsi0 to this pad." }
                      { value: "11", name: "port_dvsi0_cfg7", desc: "Connect port cfg7 from port group dvsi0 to this pad." }
                      { value: "12", name: "port_dvsi0_off0", desc: "Connect port off0 from port group dvsi0 to this pad." }
                      { value: "13", name: "port_dvsi0_off1", desc: "Connect port off1 from port group dvsi0 to this pad." }
                      { value: "14", name: "port_dvsi0_off2", desc: "Connect port off2 from port group dvsi0 to this pad." }
                      { value: "15", name: "port_dvsi0_off3", desc: "Connect port off3 from port group dvsi0 to this pad." }
                      { value: "16", name: "port_dvsi0_on0", desc: "Connect port on0 from port group dvsi0 to this pad." }
                      { value: "17", name: "port_dvsi0_on1", desc: "Connect port on1 from port group dvsi0 to this pad." }
                      { value: "18", name: "port_dvsi0_on2", desc: "Connect port on2 from port group dvsi0 to this pad." }
                      { value: "19", name: "port_dvsi0_on3", desc: "Connect port on3 from port group dvsi0 to this pad." }
                      { value: "20", name: "port_dvsi0_sxy", desc: "Connect port sxy from port group dvsi0 to this pad." }
                      { value: "21", name: "port_dvsi0_xclk", desc: "Connect port xclk from port group dvsi0 to this pad." }
                      { value: "22", name: "port_dvsi0_xnrst", desc: "Connect port xnrst from port group dvsi0 to this pad." }
                      { value: "23", name: "port_dvsi0_xydata0", desc: "Connect port xydata0 from port group dvsi0 to this pad." }
                      { value: "24", name: "port_dvsi0_xydata1", desc: "Connect port xydata1 from port group dvsi0 to this pad." }
                      { value: "25", name: "port_dvsi0_xydata2", desc: "Connect port xydata2 from port group dvsi0 to this pad." }
                      { value: "26", name: "port_dvsi0_xydata3", desc: "Connect port xydata3 from port group dvsi0 to this pad." }
                      { value: "27", name: "port_dvsi0_xydata4", desc: "Connect port xydata4 from port group dvsi0 to this pad." }
                      { value: "28", name: "port_dvsi0_xydata5", desc: "Connect port xydata5 from port group dvsi0 to this pad." }
                      { value: "29", name: "port_dvsi0_xydata6", desc: "Connect port xydata6 from port group dvsi0 to this pad." }
                      { value: "30", name: "port_dvsi0_xydata7", desc: "Connect port xydata7 from port group dvsi0 to this pad." }
                      { value: "31", name: "port_dvsi0_yclk", desc: "Connect port yclk from port group dvsi0 to this pad." }
                      { value: "32", name: "port_dvsi0_ynrst", desc: "Connect port ynrst from port group dvsi0 to this pad." }
                      { value: "33", name: "port_gpio_a_gpio11", desc: "Connect port gpio11 from port group gpio_a to this pad." }
                      { value: "34", name: "port_i2c0_i2c_scl", desc: "Connect port i2c_scl from port group i2c0 to this pad." }
                      { value: "35", name: "port_i2c0_i2c_sda", desc: "Connect port i2c_sda from port group i2c0 to this pad." }
                      { value: "36", name: "port_i2c1_i2c_scl", desc: "Connect port i2c_scl from port group i2c1 to this pad." }
                      { value: "37", name: "port_i2c1_i2c_sda", desc: "Connect port i2c_sda from port group i2c1 to this pad." }
                      { value: "38", name: "port_i2c2_i2c_scl", desc: "Connect port i2c_scl from port group i2c2 to this pad." }
                      { value: "39", name: "port_i2c2_i2c_sda", desc: "Connect port i2c_sda from port group i2c2 to this pad." }
                      { value: "40", name: "port_i2c3_i2c_scl", desc: "Connect port i2c_scl from port group i2c3 to this pad." }
                      { value: "41", name: "port_i2c3_i2c_sda", desc: "Connect port i2c_sda from port group i2c3 to this pad." }
                      { value: "42", name: "port_uart0_rx", desc: "Connect port rx from port group uart0 to this pad." }
                      { value: "43", name: "port_uart0_tx", desc: "Connect port tx from port group uart0 to this pad." }
                      { value: "44", name: "port_uart1_rx", desc: "Connect port rx from port group uart1 to this pad." }
                      { value: "45", name: "port_uart1_tx", desc: "Connect port tx from port group uart1 to this pad." }
                  ]
              }
          ]
      }

      {
          name: PAD_GPIOA12_CFG
          desc: '''
            Pad signal configuration.
          '''
          swaccess: "rw"
          fields: [
            {
                bits: "0"
                name: chip2pad
                desc: '''
                     The signal that connects to the pads TX driver
                '''
                swaccess: "rw"
                hwaccess: "hro"
                resval: "0"
            },
            {
                bits: "2:1"
                name: drv
                desc: '''
                     Driving strength selector
                '''
                swaccess: "rw"
                hwaccess: "hro"
                resval: "3"
            },
            {
                bits: "3"
                name: pde
                desc: '''
                     Pull down resistor enable
                '''
                swaccess: "rw"
                hwaccess: "hro"
                resval: "0"
            },
            {
                bits: "4"
                name: pue
                desc: '''
                     Pull up resistor enable
                '''
                swaccess: "rw"
                hwaccess: "hro"
                resval: "0"
            },
            {
                bits: "5"
                name: rxe
                desc: '''
                     Active high RX driver enable 
                '''
                swaccess: "rw"
                hwaccess: "hro"
                resval: "1"
            },
            {
                bits: "6"
                name: slw
                desc: '''
                     
                '''
                swaccess: "rw"
                hwaccess: "hro"
                resval: "0"
            },
            {
                bits: "7"
                name: smt
                desc: '''
                     Schmit trigger enable
                '''
                swaccess: "rw"
                hwaccess: "hro"
                resval: "0"
            },
            {
                bits: "8"
                name: trie
                desc: '''
                      Active high tri-state enable (active low TX driver enable)
                '''
                swaccess: "rw"
                hwaccess: "hro"
                resval: "1"
            },
          ]
      }

       {
          name: PAD_GPIOA12_MUX_SEL
          desc: '''
              Pad signal port multiplex selection for pad pad_gpioa12. The programmed value defines which port
              is connected to the pad.
          '''
          swaccess: "rw"
          hwaccess: "hro"
          resval: 0
          fields: [
              {
                  name: sel
                  desc: "Port selection index for pad pad_gpioa12."
                  bits: "5:0"
                  enum: [
                      { value: "0", name: "register", desc: "Connects the Pad to the internal configuration register."}
                      { value: "1", name: "port_dvsi0_are", desc: "Connect port are from port group dvsi0 to this pad." }
                      { value: "2", name: "port_dvsi0_asa", desc: "Connect port asa from port group dvsi0 to this pad." }
                      { value: "3", name: "port_dvsi0_asy", desc: "Connect port asy from port group dvsi0 to this pad." }
                      { value: "4", name: "port_dvsi0_cfg0", desc: "Connect port cfg0 from port group dvsi0 to this pad." }
                      { value: "5", name: "port_dvsi0_cfg1", desc: "Connect port cfg1 from port group dvsi0 to this pad." }
                      { value: "6", name: "port_dvsi0_cfg2", desc: "Connect port cfg2 from port group dvsi0 to this pad." }
                      { value: "7", name: "port_dvsi0_cfg3", desc: "Connect port cfg3 from port group dvsi0 to this pad." }
                      { value: "8", name: "port_dvsi0_cfg4", desc: "Connect port cfg4 from port group dvsi0 to this pad." }
                      { value: "9", name: "port_dvsi0_cfg5", desc: "Connect port cfg5 from port group dvsi0 to this pad." }
                      { value: "10", name: "port_dvsi0_cfg6", desc: "Connect port cfg6 from port group dvsi0 to this pad." }
                      { value: "11", name: "port_dvsi0_cfg7", desc: "Connect port cfg7 from port group dvsi0 to this pad." }
                      { value: "12", name: "port_dvsi0_off0", desc: "Connect port off0 from port group dvsi0 to this pad." }
                      { value: "13", name: "port_dvsi0_off1", desc: "Connect port off1 from port group dvsi0 to this pad." }
                      { value: "14", name: "port_dvsi0_off2", desc: "Connect port off2 from port group dvsi0 to this pad." }
                      { value: "15", name: "port_dvsi0_off3", desc: "Connect port off3 from port group dvsi0 to this pad." }
                      { value: "16", name: "port_dvsi0_on0", desc: "Connect port on0 from port group dvsi0 to this pad." }
                      { value: "17", name: "port_dvsi0_on1", desc: "Connect port on1 from port group dvsi0 to this pad." }
                      { value: "18", name: "port_dvsi0_on2", desc: "Connect port on2 from port group dvsi0 to this pad." }
                      { value: "19", name: "port_dvsi0_on3", desc: "Connect port on3 from port group dvsi0 to this pad." }
                      { value: "20", name: "port_dvsi0_sxy", desc: "Connect port sxy from port group dvsi0 to this pad." }
                      { value: "21", name: "port_dvsi0_xclk", desc: "Connect port xclk from port group dvsi0 to this pad." }
                      { value: "22", name: "port_dvsi0_xnrst", desc: "Connect port xnrst from port group dvsi0 to this pad." }
                      { value: "23", name: "port_dvsi0_xydata0", desc: "Connect port xydata0 from port group dvsi0 to this pad." }
                      { value: "24", name: "port_dvsi0_xydata1", desc: "Connect port xydata1 from port group dvsi0 to this pad." }
                      { value: "25", name: "port_dvsi0_xydata2", desc: "Connect port xydata2 from port group dvsi0 to this pad." }
                      { value: "26", name: "port_dvsi0_xydata3", desc: "Connect port xydata3 from port group dvsi0 to this pad." }
                      { value: "27", name: "port_dvsi0_xydata4", desc: "Connect port xydata4 from port group dvsi0 to this pad." }
                      { value: "28", name: "port_dvsi0_xydata5", desc: "Connect port xydata5 from port group dvsi0 to this pad." }
                      { value: "29", name: "port_dvsi0_xydata6", desc: "Connect port xydata6 from port group dvsi0 to this pad." }
                      { value: "30", name: "port_dvsi0_xydata7", desc: "Connect port xydata7 from port group dvsi0 to this pad." }
                      { value: "31", name: "port_dvsi0_yclk", desc: "Connect port yclk from port group dvsi0 to this pad." }
                      { value: "32", name: "port_dvsi0_ynrst", desc: "Connect port ynrst from port group dvsi0 to this pad." }
                      { value: "33", name: "port_gpio_a_gpio12", desc: "Connect port gpio12 from port group gpio_a to this pad." }
                      { value: "34", name: "port_i2c0_i2c_scl", desc: "Connect port i2c_scl from port group i2c0 to this pad." }
                      { value: "35", name: "port_i2c0_i2c_sda", desc: "Connect port i2c_sda from port group i2c0 to this pad." }
                      { value: "36", name: "port_i2c1_i2c_scl", desc: "Connect port i2c_scl from port group i2c1 to this pad." }
                      { value: "37", name: "port_i2c1_i2c_sda", desc: "Connect port i2c_sda from port group i2c1 to this pad." }
                      { value: "38", name: "port_i2c2_i2c_scl", desc: "Connect port i2c_scl from port group i2c2 to this pad." }
                      { value: "39", name: "port_i2c2_i2c_sda", desc: "Connect port i2c_sda from port group i2c2 to this pad." }
                      { value: "40", name: "port_i2c3_i2c_scl", desc: "Connect port i2c_scl from port group i2c3 to this pad." }
                      { value: "41", name: "port_i2c3_i2c_sda", desc: "Connect port i2c_sda from port group i2c3 to this pad." }
                      { value: "42", name: "port_uart0_rx", desc: "Connect port rx from port group uart0 to this pad." }
                      { value: "43", name: "port_uart0_tx", desc: "Connect port tx from port group uart0 to this pad." }
                      { value: "44", name: "port_uart1_rx", desc: "Connect port rx from port group uart1 to this pad." }
                      { value: "45", name: "port_uart1_tx", desc: "Connect port tx from port group uart1 to this pad." }
                  ]
              }
          ]
      }

      {
          name: PAD_GPIOA13_CFG
          desc: '''
            Pad signal configuration.
          '''
          swaccess: "rw"
          fields: [
            {
                bits: "0"
                name: chip2pad
                desc: '''
                     The signal that connects to the pads TX driver
                '''
                swaccess: "rw"
                hwaccess: "hro"
                resval: "0"
            },
            {
                bits: "2:1"
                name: drv
                desc: '''
                     Driving strength selector
                '''
                swaccess: "rw"
                hwaccess: "hro"
                resval: "3"
            },
            {
                bits: "3"
                name: pde
                desc: '''
                     Pull down resistor enable
                '''
                swaccess: "rw"
                hwaccess: "hro"
                resval: "0"
            },
            {
                bits: "4"
                name: pue
                desc: '''
                     Pull up resistor enable
                '''
                swaccess: "rw"
                hwaccess: "hro"
                resval: "0"
            },
            {
                bits: "5"
                name: rxe
                desc: '''
                     Active high RX driver enable 
                '''
                swaccess: "rw"
                hwaccess: "hro"
                resval: "1"
            },
            {
                bits: "6"
                name: slw
                desc: '''
                     
                '''
                swaccess: "rw"
                hwaccess: "hro"
                resval: "0"
            },
            {
                bits: "7"
                name: smt
                desc: '''
                     Schmit trigger enable
                '''
                swaccess: "rw"
                hwaccess: "hro"
                resval: "0"
            },
            {
                bits: "8"
                name: trie
                desc: '''
                      Active high tri-state enable (active low TX driver enable)
                '''
                swaccess: "rw"
                hwaccess: "hro"
                resval: "1"
            },
          ]
      }

       {
          name: PAD_GPIOA13_MUX_SEL
          desc: '''
              Pad signal port multiplex selection for pad pad_gpioa13. The programmed value defines which port
              is connected to the pad.
          '''
          swaccess: "rw"
          hwaccess: "hro"
          resval: 0
          fields: [
              {
                  name: sel
                  desc: "Port selection index for pad pad_gpioa13."
                  bits: "5:0"
                  enum: [
                      { value: "0", name: "register", desc: "Connects the Pad to the internal configuration register."}
                      { value: "1", name: "port_dvsi0_are", desc: "Connect port are from port group dvsi0 to this pad." }
                      { value: "2", name: "port_dvsi0_asa", desc: "Connect port asa from port group dvsi0 to this pad." }
                      { value: "3", name: "port_dvsi0_asy", desc: "Connect port asy from port group dvsi0 to this pad." }
                      { value: "4", name: "port_dvsi0_cfg0", desc: "Connect port cfg0 from port group dvsi0 to this pad." }
                      { value: "5", name: "port_dvsi0_cfg1", desc: "Connect port cfg1 from port group dvsi0 to this pad." }
                      { value: "6", name: "port_dvsi0_cfg2", desc: "Connect port cfg2 from port group dvsi0 to this pad." }
                      { value: "7", name: "port_dvsi0_cfg3", desc: "Connect port cfg3 from port group dvsi0 to this pad." }
                      { value: "8", name: "port_dvsi0_cfg4", desc: "Connect port cfg4 from port group dvsi0 to this pad." }
                      { value: "9", name: "port_dvsi0_cfg5", desc: "Connect port cfg5 from port group dvsi0 to this pad." }
                      { value: "10", name: "port_dvsi0_cfg6", desc: "Connect port cfg6 from port group dvsi0 to this pad." }
                      { value: "11", name: "port_dvsi0_cfg7", desc: "Connect port cfg7 from port group dvsi0 to this pad." }
                      { value: "12", name: "port_dvsi0_off0", desc: "Connect port off0 from port group dvsi0 to this pad." }
                      { value: "13", name: "port_dvsi0_off1", desc: "Connect port off1 from port group dvsi0 to this pad." }
                      { value: "14", name: "port_dvsi0_off2", desc: "Connect port off2 from port group dvsi0 to this pad." }
                      { value: "15", name: "port_dvsi0_off3", desc: "Connect port off3 from port group dvsi0 to this pad." }
                      { value: "16", name: "port_dvsi0_on0", desc: "Connect port on0 from port group dvsi0 to this pad." }
                      { value: "17", name: "port_dvsi0_on1", desc: "Connect port on1 from port group dvsi0 to this pad." }
                      { value: "18", name: "port_dvsi0_on2", desc: "Connect port on2 from port group dvsi0 to this pad." }
                      { value: "19", name: "port_dvsi0_on3", desc: "Connect port on3 from port group dvsi0 to this pad." }
                      { value: "20", name: "port_dvsi0_sxy", desc: "Connect port sxy from port group dvsi0 to this pad." }
                      { value: "21", name: "port_dvsi0_xclk", desc: "Connect port xclk from port group dvsi0 to this pad." }
                      { value: "22", name: "port_dvsi0_xnrst", desc: "Connect port xnrst from port group dvsi0 to this pad." }
                      { value: "23", name: "port_dvsi0_xydata0", desc: "Connect port xydata0 from port group dvsi0 to this pad." }
                      { value: "24", name: "port_dvsi0_xydata1", desc: "Connect port xydata1 from port group dvsi0 to this pad." }
                      { value: "25", name: "port_dvsi0_xydata2", desc: "Connect port xydata2 from port group dvsi0 to this pad." }
                      { value: "26", name: "port_dvsi0_xydata3", desc: "Connect port xydata3 from port group dvsi0 to this pad." }
                      { value: "27", name: "port_dvsi0_xydata4", desc: "Connect port xydata4 from port group dvsi0 to this pad." }
                      { value: "28", name: "port_dvsi0_xydata5", desc: "Connect port xydata5 from port group dvsi0 to this pad." }
                      { value: "29", name: "port_dvsi0_xydata6", desc: "Connect port xydata6 from port group dvsi0 to this pad." }
                      { value: "30", name: "port_dvsi0_xydata7", desc: "Connect port xydata7 from port group dvsi0 to this pad." }
                      { value: "31", name: "port_dvsi0_yclk", desc: "Connect port yclk from port group dvsi0 to this pad." }
                      { value: "32", name: "port_dvsi0_ynrst", desc: "Connect port ynrst from port group dvsi0 to this pad." }
                      { value: "33", name: "port_gpio_a_gpio13", desc: "Connect port gpio13 from port group gpio_a to this pad." }
                      { value: "34", name: "port_i2c0_i2c_scl", desc: "Connect port i2c_scl from port group i2c0 to this pad." }
                      { value: "35", name: "port_i2c0_i2c_sda", desc: "Connect port i2c_sda from port group i2c0 to this pad." }
                      { value: "36", name: "port_i2c1_i2c_scl", desc: "Connect port i2c_scl from port group i2c1 to this pad." }
                      { value: "37", name: "port_i2c1_i2c_sda", desc: "Connect port i2c_sda from port group i2c1 to this pad." }
                      { value: "38", name: "port_i2c2_i2c_scl", desc: "Connect port i2c_scl from port group i2c2 to this pad." }
                      { value: "39", name: "port_i2c2_i2c_sda", desc: "Connect port i2c_sda from port group i2c2 to this pad." }
                      { value: "40", name: "port_i2c3_i2c_scl", desc: "Connect port i2c_scl from port group i2c3 to this pad." }
                      { value: "41", name: "port_i2c3_i2c_sda", desc: "Connect port i2c_sda from port group i2c3 to this pad." }
                      { value: "42", name: "port_uart0_rx", desc: "Connect port rx from port group uart0 to this pad." }
                      { value: "43", name: "port_uart0_tx", desc: "Connect port tx from port group uart0 to this pad." }
                      { value: "44", name: "port_uart1_rx", desc: "Connect port rx from port group uart1 to this pad." }
                      { value: "45", name: "port_uart1_tx", desc: "Connect port tx from port group uart1 to this pad." }
                  ]
              }
          ]
      }

      {
          name: PAD_GPIOA14_CFG
          desc: '''
            Pad signal configuration.
          '''
          swaccess: "rw"
          fields: [
            {
                bits: "0"
                name: chip2pad
                desc: '''
                     The signal that connects to the pads TX driver
                '''
                swaccess: "rw"
                hwaccess: "hro"
                resval: "0"
            },
            {
                bits: "2:1"
                name: drv
                desc: '''
                     Driving strength selector
                '''
                swaccess: "rw"
                hwaccess: "hro"
                resval: "3"
            },
            {
                bits: "3"
                name: pde
                desc: '''
                     Pull down resistor enable
                '''
                swaccess: "rw"
                hwaccess: "hro"
                resval: "0"
            },
            {
                bits: "4"
                name: pue
                desc: '''
                     Pull up resistor enable
                '''
                swaccess: "rw"
                hwaccess: "hro"
                resval: "0"
            },
            {
                bits: "5"
                name: rxe
                desc: '''
                     Active high RX driver enable 
                '''
                swaccess: "rw"
                hwaccess: "hro"
                resval: "1"
            },
            {
                bits: "6"
                name: slw
                desc: '''
                     
                '''
                swaccess: "rw"
                hwaccess: "hro"
                resval: "0"
            },
            {
                bits: "7"
                name: smt
                desc: '''
                     Schmit trigger enable
                '''
                swaccess: "rw"
                hwaccess: "hro"
                resval: "0"
            },
            {
                bits: "8"
                name: trie
                desc: '''
                      Active high tri-state enable (active low TX driver enable)
                '''
                swaccess: "rw"
                hwaccess: "hro"
                resval: "1"
            },
          ]
      }

       {
          name: PAD_GPIOA14_MUX_SEL
          desc: '''
              Pad signal port multiplex selection for pad pad_gpioa14. The programmed value defines which port
              is connected to the pad.
          '''
          swaccess: "rw"
          hwaccess: "hro"
          resval: 0
          fields: [
              {
                  name: sel
                  desc: "Port selection index for pad pad_gpioa14."
                  bits: "5:0"
                  enum: [
                      { value: "0", name: "register", desc: "Connects the Pad to the internal configuration register."}
                      { value: "1", name: "port_dvsi0_are", desc: "Connect port are from port group dvsi0 to this pad." }
                      { value: "2", name: "port_dvsi0_asa", desc: "Connect port asa from port group dvsi0 to this pad." }
                      { value: "3", name: "port_dvsi0_asy", desc: "Connect port asy from port group dvsi0 to this pad." }
                      { value: "4", name: "port_dvsi0_cfg0", desc: "Connect port cfg0 from port group dvsi0 to this pad." }
                      { value: "5", name: "port_dvsi0_cfg1", desc: "Connect port cfg1 from port group dvsi0 to this pad." }
                      { value: "6", name: "port_dvsi0_cfg2", desc: "Connect port cfg2 from port group dvsi0 to this pad." }
                      { value: "7", name: "port_dvsi0_cfg3", desc: "Connect port cfg3 from port group dvsi0 to this pad." }
                      { value: "8", name: "port_dvsi0_cfg4", desc: "Connect port cfg4 from port group dvsi0 to this pad." }
                      { value: "9", name: "port_dvsi0_cfg5", desc: "Connect port cfg5 from port group dvsi0 to this pad." }
                      { value: "10", name: "port_dvsi0_cfg6", desc: "Connect port cfg6 from port group dvsi0 to this pad." }
                      { value: "11", name: "port_dvsi0_cfg7", desc: "Connect port cfg7 from port group dvsi0 to this pad." }
                      { value: "12", name: "port_dvsi0_off0", desc: "Connect port off0 from port group dvsi0 to this pad." }
                      { value: "13", name: "port_dvsi0_off1", desc: "Connect port off1 from port group dvsi0 to this pad." }
                      { value: "14", name: "port_dvsi0_off2", desc: "Connect port off2 from port group dvsi0 to this pad." }
                      { value: "15", name: "port_dvsi0_off3", desc: "Connect port off3 from port group dvsi0 to this pad." }
                      { value: "16", name: "port_dvsi0_on0", desc: "Connect port on0 from port group dvsi0 to this pad." }
                      { value: "17", name: "port_dvsi0_on1", desc: "Connect port on1 from port group dvsi0 to this pad." }
                      { value: "18", name: "port_dvsi0_on2", desc: "Connect port on2 from port group dvsi0 to this pad." }
                      { value: "19", name: "port_dvsi0_on3", desc: "Connect port on3 from port group dvsi0 to this pad." }
                      { value: "20", name: "port_dvsi0_sxy", desc: "Connect port sxy from port group dvsi0 to this pad." }
                      { value: "21", name: "port_dvsi0_xclk", desc: "Connect port xclk from port group dvsi0 to this pad." }
                      { value: "22", name: "port_dvsi0_xnrst", desc: "Connect port xnrst from port group dvsi0 to this pad." }
                      { value: "23", name: "port_dvsi0_xydata0", desc: "Connect port xydata0 from port group dvsi0 to this pad." }
                      { value: "24", name: "port_dvsi0_xydata1", desc: "Connect port xydata1 from port group dvsi0 to this pad." }
                      { value: "25", name: "port_dvsi0_xydata2", desc: "Connect port xydata2 from port group dvsi0 to this pad." }
                      { value: "26", name: "port_dvsi0_xydata3", desc: "Connect port xydata3 from port group dvsi0 to this pad." }
                      { value: "27", name: "port_dvsi0_xydata4", desc: "Connect port xydata4 from port group dvsi0 to this pad." }
                      { value: "28", name: "port_dvsi0_xydata5", desc: "Connect port xydata5 from port group dvsi0 to this pad." }
                      { value: "29", name: "port_dvsi0_xydata6", desc: "Connect port xydata6 from port group dvsi0 to this pad." }
                      { value: "30", name: "port_dvsi0_xydata7", desc: "Connect port xydata7 from port group dvsi0 to this pad." }
                      { value: "31", name: "port_dvsi0_yclk", desc: "Connect port yclk from port group dvsi0 to this pad." }
                      { value: "32", name: "port_dvsi0_ynrst", desc: "Connect port ynrst from port group dvsi0 to this pad." }
                      { value: "33", name: "port_gpio_a_gpio14", desc: "Connect port gpio14 from port group gpio_a to this pad." }
                      { value: "34", name: "port_i2c0_i2c_scl", desc: "Connect port i2c_scl from port group i2c0 to this pad." }
                      { value: "35", name: "port_i2c0_i2c_sda", desc: "Connect port i2c_sda from port group i2c0 to this pad." }
                      { value: "36", name: "port_i2c1_i2c_scl", desc: "Connect port i2c_scl from port group i2c1 to this pad." }
                      { value: "37", name: "port_i2c1_i2c_sda", desc: "Connect port i2c_sda from port group i2c1 to this pad." }
                      { value: "38", name: "port_i2c2_i2c_scl", desc: "Connect port i2c_scl from port group i2c2 to this pad." }
                      { value: "39", name: "port_i2c2_i2c_sda", desc: "Connect port i2c_sda from port group i2c2 to this pad." }
                      { value: "40", name: "port_i2c3_i2c_scl", desc: "Connect port i2c_scl from port group i2c3 to this pad." }
                      { value: "41", name: "port_i2c3_i2c_sda", desc: "Connect port i2c_sda from port group i2c3 to this pad." }
                      { value: "42", name: "port_uart0_rx", desc: "Connect port rx from port group uart0 to this pad." }
                      { value: "43", name: "port_uart0_tx", desc: "Connect port tx from port group uart0 to this pad." }
                      { value: "44", name: "port_uart1_rx", desc: "Connect port rx from port group uart1 to this pad." }
                      { value: "45", name: "port_uart1_tx", desc: "Connect port tx from port group uart1 to this pad." }
                  ]
              }
          ]
      }

      {
          name: PAD_GPIOA15_CFG
          desc: '''
            Pad signal configuration.
          '''
          swaccess: "rw"
          fields: [
            {
                bits: "0"
                name: chip2pad
                desc: '''
                     The signal that connects to the pads TX driver
                '''
                swaccess: "rw"
                hwaccess: "hro"
                resval: "0"
            },
            {
                bits: "2:1"
                name: drv
                desc: '''
                     Driving strength selector
                '''
                swaccess: "rw"
                hwaccess: "hro"
                resval: "3"
            },
            {
                bits: "3"
                name: pde
                desc: '''
                     Pull down resistor enable
                '''
                swaccess: "rw"
                hwaccess: "hro"
                resval: "0"
            },
            {
                bits: "4"
                name: pue
                desc: '''
                     Pull up resistor enable
                '''
                swaccess: "rw"
                hwaccess: "hro"
                resval: "0"
            },
            {
                bits: "5"
                name: rxe
                desc: '''
                     Active high RX driver enable 
                '''
                swaccess: "rw"
                hwaccess: "hro"
                resval: "1"
            },
            {
                bits: "6"
                name: slw
                desc: '''
                     
                '''
                swaccess: "rw"
                hwaccess: "hro"
                resval: "0"
            },
            {
                bits: "7"
                name: smt
                desc: '''
                     Schmit trigger enable
                '''
                swaccess: "rw"
                hwaccess: "hro"
                resval: "0"
            },
            {
                bits: "8"
                name: trie
                desc: '''
                      Active high tri-state enable (active low TX driver enable)
                '''
                swaccess: "rw"
                hwaccess: "hro"
                resval: "1"
            },
          ]
      }

       {
          name: PAD_GPIOA15_MUX_SEL
          desc: '''
              Pad signal port multiplex selection for pad pad_gpioa15. The programmed value defines which port
              is connected to the pad.
          '''
          swaccess: "rw"
          hwaccess: "hro"
          resval: 0
          fields: [
              {
                  name: sel
                  desc: "Port selection index for pad pad_gpioa15."
                  bits: "5:0"
                  enum: [
                      { value: "0", name: "register", desc: "Connects the Pad to the internal configuration register."}
                      { value: "1", name: "port_dvsi0_are", desc: "Connect port are from port group dvsi0 to this pad." }
                      { value: "2", name: "port_dvsi0_asa", desc: "Connect port asa from port group dvsi0 to this pad." }
                      { value: "3", name: "port_dvsi0_asy", desc: "Connect port asy from port group dvsi0 to this pad." }
                      { value: "4", name: "port_dvsi0_cfg0", desc: "Connect port cfg0 from port group dvsi0 to this pad." }
                      { value: "5", name: "port_dvsi0_cfg1", desc: "Connect port cfg1 from port group dvsi0 to this pad." }
                      { value: "6", name: "port_dvsi0_cfg2", desc: "Connect port cfg2 from port group dvsi0 to this pad." }
                      { value: "7", name: "port_dvsi0_cfg3", desc: "Connect port cfg3 from port group dvsi0 to this pad." }
                      { value: "8", name: "port_dvsi0_cfg4", desc: "Connect port cfg4 from port group dvsi0 to this pad." }
                      { value: "9", name: "port_dvsi0_cfg5", desc: "Connect port cfg5 from port group dvsi0 to this pad." }
                      { value: "10", name: "port_dvsi0_cfg6", desc: "Connect port cfg6 from port group dvsi0 to this pad." }
                      { value: "11", name: "port_dvsi0_cfg7", desc: "Connect port cfg7 from port group dvsi0 to this pad." }
                      { value: "12", name: "port_dvsi0_off0", desc: "Connect port off0 from port group dvsi0 to this pad." }
                      { value: "13", name: "port_dvsi0_off1", desc: "Connect port off1 from port group dvsi0 to this pad." }
                      { value: "14", name: "port_dvsi0_off2", desc: "Connect port off2 from port group dvsi0 to this pad." }
                      { value: "15", name: "port_dvsi0_off3", desc: "Connect port off3 from port group dvsi0 to this pad." }
                      { value: "16", name: "port_dvsi0_on0", desc: "Connect port on0 from port group dvsi0 to this pad." }
                      { value: "17", name: "port_dvsi0_on1", desc: "Connect port on1 from port group dvsi0 to this pad." }
                      { value: "18", name: "port_dvsi0_on2", desc: "Connect port on2 from port group dvsi0 to this pad." }
                      { value: "19", name: "port_dvsi0_on3", desc: "Connect port on3 from port group dvsi0 to this pad." }
                      { value: "20", name: "port_dvsi0_sxy", desc: "Connect port sxy from port group dvsi0 to this pad." }
                      { value: "21", name: "port_dvsi0_xclk", desc: "Connect port xclk from port group dvsi0 to this pad." }
                      { value: "22", name: "port_dvsi0_xnrst", desc: "Connect port xnrst from port group dvsi0 to this pad." }
                      { value: "23", name: "port_dvsi0_xydata0", desc: "Connect port xydata0 from port group dvsi0 to this pad." }
                      { value: "24", name: "port_dvsi0_xydata1", desc: "Connect port xydata1 from port group dvsi0 to this pad." }
                      { value: "25", name: "port_dvsi0_xydata2", desc: "Connect port xydata2 from port group dvsi0 to this pad." }
                      { value: "26", name: "port_dvsi0_xydata3", desc: "Connect port xydata3 from port group dvsi0 to this pad." }
                      { value: "27", name: "port_dvsi0_xydata4", desc: "Connect port xydata4 from port group dvsi0 to this pad." }
                      { value: "28", name: "port_dvsi0_xydata5", desc: "Connect port xydata5 from port group dvsi0 to this pad." }
                      { value: "29", name: "port_dvsi0_xydata6", desc: "Connect port xydata6 from port group dvsi0 to this pad." }
                      { value: "30", name: "port_dvsi0_xydata7", desc: "Connect port xydata7 from port group dvsi0 to this pad." }
                      { value: "31", name: "port_dvsi0_yclk", desc: "Connect port yclk from port group dvsi0 to this pad." }
                      { value: "32", name: "port_dvsi0_ynrst", desc: "Connect port ynrst from port group dvsi0 to this pad." }
                      { value: "33", name: "port_gpio_a_gpio15", desc: "Connect port gpio15 from port group gpio_a to this pad." }
                      { value: "34", name: "port_i2c0_i2c_scl", desc: "Connect port i2c_scl from port group i2c0 to this pad." }
                      { value: "35", name: "port_i2c0_i2c_sda", desc: "Connect port i2c_sda from port group i2c0 to this pad." }
                      { value: "36", name: "port_i2c1_i2c_scl", desc: "Connect port i2c_scl from port group i2c1 to this pad." }
                      { value: "37", name: "port_i2c1_i2c_sda", desc: "Connect port i2c_sda from port group i2c1 to this pad." }
                      { value: "38", name: "port_i2c2_i2c_scl", desc: "Connect port i2c_scl from port group i2c2 to this pad." }
                      { value: "39", name: "port_i2c2_i2c_sda", desc: "Connect port i2c_sda from port group i2c2 to this pad." }
                      { value: "40", name: "port_i2c3_i2c_scl", desc: "Connect port i2c_scl from port group i2c3 to this pad." }
                      { value: "41", name: "port_i2c3_i2c_sda", desc: "Connect port i2c_sda from port group i2c3 to this pad." }
                      { value: "42", name: "port_uart0_rx", desc: "Connect port rx from port group uart0 to this pad." }
                      { value: "43", name: "port_uart0_tx", desc: "Connect port tx from port group uart0 to this pad." }
                      { value: "44", name: "port_uart1_rx", desc: "Connect port rx from port group uart1 to this pad." }
                      { value: "45", name: "port_uart1_tx", desc: "Connect port tx from port group uart1 to this pad." }
                  ]
              }
          ]
      }

      {
          name: PAD_GPIOA16_CFG
          desc: '''
            Pad signal configuration.
          '''
          swaccess: "rw"
          fields: [
            {
                bits: "0"
                name: chip2pad
                desc: '''
                     The signal that connects to the pads TX driver
                '''
                swaccess: "rw"
                hwaccess: "hro"
                resval: "0"
            },
            {
                bits: "2:1"
                name: drv
                desc: '''
                     Driving strength selector
                '''
                swaccess: "rw"
                hwaccess: "hro"
                resval: "3"
            },
            {
                bits: "3"
                name: pde
                desc: '''
                     Pull down resistor enable
                '''
                swaccess: "rw"
                hwaccess: "hro"
                resval: "0"
            },
            {
                bits: "4"
                name: pue
                desc: '''
                     Pull up resistor enable
                '''
                swaccess: "rw"
                hwaccess: "hro"
                resval: "0"
            },
            {
                bits: "5"
                name: rxe
                desc: '''
                     Active high RX driver enable 
                '''
                swaccess: "rw"
                hwaccess: "hro"
                resval: "1"
            },
            {
                bits: "6"
                name: slw
                desc: '''
                     
                '''
                swaccess: "rw"
                hwaccess: "hro"
                resval: "0"
            },
            {
                bits: "7"
                name: smt
                desc: '''
                     Schmit trigger enable
                '''
                swaccess: "rw"
                hwaccess: "hro"
                resval: "0"
            },
            {
                bits: "8"
                name: trie
                desc: '''
                      Active high tri-state enable (active low TX driver enable)
                '''
                swaccess: "rw"
                hwaccess: "hro"
                resval: "1"
            },
          ]
      }

       {
          name: PAD_GPIOA16_MUX_SEL
          desc: '''
              Pad signal port multiplex selection for pad pad_gpioa16. The programmed value defines which port
              is connected to the pad.
          '''
          swaccess: "rw"
          hwaccess: "hro"
          resval: 0
          fields: [
              {
                  name: sel
                  desc: "Port selection index for pad pad_gpioa16."
                  bits: "5:0"
                  enum: [
                      { value: "0", name: "register", desc: "Connects the Pad to the internal configuration register."}
                      { value: "1", name: "port_dvsi0_are", desc: "Connect port are from port group dvsi0 to this pad." }
                      { value: "2", name: "port_dvsi0_asa", desc: "Connect port asa from port group dvsi0 to this pad." }
                      { value: "3", name: "port_dvsi0_asy", desc: "Connect port asy from port group dvsi0 to this pad." }
                      { value: "4", name: "port_dvsi0_cfg0", desc: "Connect port cfg0 from port group dvsi0 to this pad." }
                      { value: "5", name: "port_dvsi0_cfg1", desc: "Connect port cfg1 from port group dvsi0 to this pad." }
                      { value: "6", name: "port_dvsi0_cfg2", desc: "Connect port cfg2 from port group dvsi0 to this pad." }
                      { value: "7", name: "port_dvsi0_cfg3", desc: "Connect port cfg3 from port group dvsi0 to this pad." }
                      { value: "8", name: "port_dvsi0_cfg4", desc: "Connect port cfg4 from port group dvsi0 to this pad." }
                      { value: "9", name: "port_dvsi0_cfg5", desc: "Connect port cfg5 from port group dvsi0 to this pad." }
                      { value: "10", name: "port_dvsi0_cfg6", desc: "Connect port cfg6 from port group dvsi0 to this pad." }
                      { value: "11", name: "port_dvsi0_cfg7", desc: "Connect port cfg7 from port group dvsi0 to this pad." }
                      { value: "12", name: "port_dvsi0_off0", desc: "Connect port off0 from port group dvsi0 to this pad." }
                      { value: "13", name: "port_dvsi0_off1", desc: "Connect port off1 from port group dvsi0 to this pad." }
                      { value: "14", name: "port_dvsi0_off2", desc: "Connect port off2 from port group dvsi0 to this pad." }
                      { value: "15", name: "port_dvsi0_off3", desc: "Connect port off3 from port group dvsi0 to this pad." }
                      { value: "16", name: "port_dvsi0_on0", desc: "Connect port on0 from port group dvsi0 to this pad." }
                      { value: "17", name: "port_dvsi0_on1", desc: "Connect port on1 from port group dvsi0 to this pad." }
                      { value: "18", name: "port_dvsi0_on2", desc: "Connect port on2 from port group dvsi0 to this pad." }
                      { value: "19", name: "port_dvsi0_on3", desc: "Connect port on3 from port group dvsi0 to this pad." }
                      { value: "20", name: "port_dvsi0_sxy", desc: "Connect port sxy from port group dvsi0 to this pad." }
                      { value: "21", name: "port_dvsi0_xclk", desc: "Connect port xclk from port group dvsi0 to this pad." }
                      { value: "22", name: "port_dvsi0_xnrst", desc: "Connect port xnrst from port group dvsi0 to this pad." }
                      { value: "23", name: "port_dvsi0_xydata0", desc: "Connect port xydata0 from port group dvsi0 to this pad." }
                      { value: "24", name: "port_dvsi0_xydata1", desc: "Connect port xydata1 from port group dvsi0 to this pad." }
                      { value: "25", name: "port_dvsi0_xydata2", desc: "Connect port xydata2 from port group dvsi0 to this pad." }
                      { value: "26", name: "port_dvsi0_xydata3", desc: "Connect port xydata3 from port group dvsi0 to this pad." }
                      { value: "27", name: "port_dvsi0_xydata4", desc: "Connect port xydata4 from port group dvsi0 to this pad." }
                      { value: "28", name: "port_dvsi0_xydata5", desc: "Connect port xydata5 from port group dvsi0 to this pad." }
                      { value: "29", name: "port_dvsi0_xydata6", desc: "Connect port xydata6 from port group dvsi0 to this pad." }
                      { value: "30", name: "port_dvsi0_xydata7", desc: "Connect port xydata7 from port group dvsi0 to this pad." }
                      { value: "31", name: "port_dvsi0_yclk", desc: "Connect port yclk from port group dvsi0 to this pad." }
                      { value: "32", name: "port_dvsi0_ynrst", desc: "Connect port ynrst from port group dvsi0 to this pad." }
                      { value: "33", name: "port_gpio_a_gpio16", desc: "Connect port gpio16 from port group gpio_a to this pad." }
                      { value: "34", name: "port_i2c0_i2c_scl", desc: "Connect port i2c_scl from port group i2c0 to this pad." }
                      { value: "35", name: "port_i2c0_i2c_sda", desc: "Connect port i2c_sda from port group i2c0 to this pad." }
                      { value: "36", name: "port_i2c1_i2c_scl", desc: "Connect port i2c_scl from port group i2c1 to this pad." }
                      { value: "37", name: "port_i2c1_i2c_sda", desc: "Connect port i2c_sda from port group i2c1 to this pad." }
                      { value: "38", name: "port_i2c2_i2c_scl", desc: "Connect port i2c_scl from port group i2c2 to this pad." }
                      { value: "39", name: "port_i2c2_i2c_sda", desc: "Connect port i2c_sda from port group i2c2 to this pad." }
                      { value: "40", name: "port_i2c3_i2c_scl", desc: "Connect port i2c_scl from port group i2c3 to this pad." }
                      { value: "41", name: "port_i2c3_i2c_sda", desc: "Connect port i2c_sda from port group i2c3 to this pad." }
                      { value: "42", name: "port_uart0_rx", desc: "Connect port rx from port group uart0 to this pad." }
                      { value: "43", name: "port_uart0_tx", desc: "Connect port tx from port group uart0 to this pad." }
                      { value: "44", name: "port_uart1_rx", desc: "Connect port rx from port group uart1 to this pad." }
                      { value: "45", name: "port_uart1_tx", desc: "Connect port tx from port group uart1 to this pad." }
                  ]
              }
          ]
      }

      {
          name: PAD_GPIOA17_CFG
          desc: '''
            Pad signal configuration.
          '''
          swaccess: "rw"
          fields: [
            {
                bits: "0"
                name: chip2pad
                desc: '''
                     The signal that connects to the pads TX driver
                '''
                swaccess: "rw"
                hwaccess: "hro"
                resval: "0"
            },
            {
                bits: "2:1"
                name: drv
                desc: '''
                     Driving strength selector
                '''
                swaccess: "rw"
                hwaccess: "hro"
                resval: "3"
            },
            {
                bits: "3"
                name: pde
                desc: '''
                     Pull down resistor enable
                '''
                swaccess: "rw"
                hwaccess: "hro"
                resval: "0"
            },
            {
                bits: "4"
                name: pue
                desc: '''
                     Pull up resistor enable
                '''
                swaccess: "rw"
                hwaccess: "hro"
                resval: "0"
            },
            {
                bits: "5"
                name: rxe
                desc: '''
                     Active high RX driver enable 
                '''
                swaccess: "rw"
                hwaccess: "hro"
                resval: "1"
            },
            {
                bits: "6"
                name: slw
                desc: '''
                     
                '''
                swaccess: "rw"
                hwaccess: "hro"
                resval: "0"
            },
            {
                bits: "7"
                name: smt
                desc: '''
                     Schmit trigger enable
                '''
                swaccess: "rw"
                hwaccess: "hro"
                resval: "0"
            },
            {
                bits: "8"
                name: trie
                desc: '''
                      Active high tri-state enable (active low TX driver enable)
                '''
                swaccess: "rw"
                hwaccess: "hro"
                resval: "1"
            },
          ]
      }

       {
          name: PAD_GPIOA17_MUX_SEL
          desc: '''
              Pad signal port multiplex selection for pad pad_gpioa17. The programmed value defines which port
              is connected to the pad.
          '''
          swaccess: "rw"
          hwaccess: "hro"
          resval: 0
          fields: [
              {
                  name: sel
                  desc: "Port selection index for pad pad_gpioa17."
                  bits: "5:0"
                  enum: [
                      { value: "0", name: "register", desc: "Connects the Pad to the internal configuration register."}
                      { value: "1", name: "port_dvsi0_are", desc: "Connect port are from port group dvsi0 to this pad." }
                      { value: "2", name: "port_dvsi0_asa", desc: "Connect port asa from port group dvsi0 to this pad." }
                      { value: "3", name: "port_dvsi0_asy", desc: "Connect port asy from port group dvsi0 to this pad." }
                      { value: "4", name: "port_dvsi0_cfg0", desc: "Connect port cfg0 from port group dvsi0 to this pad." }
                      { value: "5", name: "port_dvsi0_cfg1", desc: "Connect port cfg1 from port group dvsi0 to this pad." }
                      { value: "6", name: "port_dvsi0_cfg2", desc: "Connect port cfg2 from port group dvsi0 to this pad." }
                      { value: "7", name: "port_dvsi0_cfg3", desc: "Connect port cfg3 from port group dvsi0 to this pad." }
                      { value: "8", name: "port_dvsi0_cfg4", desc: "Connect port cfg4 from port group dvsi0 to this pad." }
                      { value: "9", name: "port_dvsi0_cfg5", desc: "Connect port cfg5 from port group dvsi0 to this pad." }
                      { value: "10", name: "port_dvsi0_cfg6", desc: "Connect port cfg6 from port group dvsi0 to this pad." }
                      { value: "11", name: "port_dvsi0_cfg7", desc: "Connect port cfg7 from port group dvsi0 to this pad." }
                      { value: "12", name: "port_dvsi0_off0", desc: "Connect port off0 from port group dvsi0 to this pad." }
                      { value: "13", name: "port_dvsi0_off1", desc: "Connect port off1 from port group dvsi0 to this pad." }
                      { value: "14", name: "port_dvsi0_off2", desc: "Connect port off2 from port group dvsi0 to this pad." }
                      { value: "15", name: "port_dvsi0_off3", desc: "Connect port off3 from port group dvsi0 to this pad." }
                      { value: "16", name: "port_dvsi0_on0", desc: "Connect port on0 from port group dvsi0 to this pad." }
                      { value: "17", name: "port_dvsi0_on1", desc: "Connect port on1 from port group dvsi0 to this pad." }
                      { value: "18", name: "port_dvsi0_on2", desc: "Connect port on2 from port group dvsi0 to this pad." }
                      { value: "19", name: "port_dvsi0_on3", desc: "Connect port on3 from port group dvsi0 to this pad." }
                      { value: "20", name: "port_dvsi0_sxy", desc: "Connect port sxy from port group dvsi0 to this pad." }
                      { value: "21", name: "port_dvsi0_xclk", desc: "Connect port xclk from port group dvsi0 to this pad." }
                      { value: "22", name: "port_dvsi0_xnrst", desc: "Connect port xnrst from port group dvsi0 to this pad." }
                      { value: "23", name: "port_dvsi0_xydata0", desc: "Connect port xydata0 from port group dvsi0 to this pad." }
                      { value: "24", name: "port_dvsi0_xydata1", desc: "Connect port xydata1 from port group dvsi0 to this pad." }
                      { value: "25", name: "port_dvsi0_xydata2", desc: "Connect port xydata2 from port group dvsi0 to this pad." }
                      { value: "26", name: "port_dvsi0_xydata3", desc: "Connect port xydata3 from port group dvsi0 to this pad." }
                      { value: "27", name: "port_dvsi0_xydata4", desc: "Connect port xydata4 from port group dvsi0 to this pad." }
                      { value: "28", name: "port_dvsi0_xydata5", desc: "Connect port xydata5 from port group dvsi0 to this pad." }
                      { value: "29", name: "port_dvsi0_xydata6", desc: "Connect port xydata6 from port group dvsi0 to this pad." }
                      { value: "30", name: "port_dvsi0_xydata7", desc: "Connect port xydata7 from port group dvsi0 to this pad." }
                      { value: "31", name: "port_dvsi0_yclk", desc: "Connect port yclk from port group dvsi0 to this pad." }
                      { value: "32", name: "port_dvsi0_ynrst", desc: "Connect port ynrst from port group dvsi0 to this pad." }
                      { value: "33", name: "port_gpio_a_gpio17", desc: "Connect port gpio17 from port group gpio_a to this pad." }
                      { value: "34", name: "port_i2c0_i2c_scl", desc: "Connect port i2c_scl from port group i2c0 to this pad." }
                      { value: "35", name: "port_i2c0_i2c_sda", desc: "Connect port i2c_sda from port group i2c0 to this pad." }
                      { value: "36", name: "port_i2c1_i2c_scl", desc: "Connect port i2c_scl from port group i2c1 to this pad." }
                      { value: "37", name: "port_i2c1_i2c_sda", desc: "Connect port i2c_sda from port group i2c1 to this pad." }
                      { value: "38", name: "port_i2c2_i2c_scl", desc: "Connect port i2c_scl from port group i2c2 to this pad." }
                      { value: "39", name: "port_i2c2_i2c_sda", desc: "Connect port i2c_sda from port group i2c2 to this pad." }
                      { value: "40", name: "port_i2c3_i2c_scl", desc: "Connect port i2c_scl from port group i2c3 to this pad." }
                      { value: "41", name: "port_i2c3_i2c_sda", desc: "Connect port i2c_sda from port group i2c3 to this pad." }
                      { value: "42", name: "port_uart0_rx", desc: "Connect port rx from port group uart0 to this pad." }
                      { value: "43", name: "port_uart0_tx", desc: "Connect port tx from port group uart0 to this pad." }
                      { value: "44", name: "port_uart1_rx", desc: "Connect port rx from port group uart1 to this pad." }
                      { value: "45", name: "port_uart1_tx", desc: "Connect port tx from port group uart1 to this pad." }
                  ]
              }
          ]
      }

      {
          name: PAD_GPIOA18_CFG
          desc: '''
            Pad signal configuration.
          '''
          swaccess: "rw"
          fields: [
            {
                bits: "0"
                name: chip2pad
                desc: '''
                     The signal that connects to the pads TX driver
                '''
                swaccess: "rw"
                hwaccess: "hro"
                resval: "0"
            },
            {
                bits: "2:1"
                name: drv
                desc: '''
                     Driving strength selector
                '''
                swaccess: "rw"
                hwaccess: "hro"
                resval: "3"
            },
            {
                bits: "3"
                name: pde
                desc: '''
                     Pull down resistor enable
                '''
                swaccess: "rw"
                hwaccess: "hro"
                resval: "0"
            },
            {
                bits: "4"
                name: pue
                desc: '''
                     Pull up resistor enable
                '''
                swaccess: "rw"
                hwaccess: "hro"
                resval: "0"
            },
            {
                bits: "5"
                name: rxe
                desc: '''
                     Active high RX driver enable 
                '''
                swaccess: "rw"
                hwaccess: "hro"
                resval: "1"
            },
            {
                bits: "6"
                name: slw
                desc: '''
                     
                '''
                swaccess: "rw"
                hwaccess: "hro"
                resval: "0"
            },
            {
                bits: "7"
                name: smt
                desc: '''
                     Schmit trigger enable
                '''
                swaccess: "rw"
                hwaccess: "hro"
                resval: "0"
            },
            {
                bits: "8"
                name: trie
                desc: '''
                      Active high tri-state enable (active low TX driver enable)
                '''
                swaccess: "rw"
                hwaccess: "hro"
                resval: "1"
            },
          ]
      }

       {
          name: PAD_GPIOA18_MUX_SEL
          desc: '''
              Pad signal port multiplex selection for pad pad_gpioa18. The programmed value defines which port
              is connected to the pad.
          '''
          swaccess: "rw"
          hwaccess: "hro"
          resval: 0
          fields: [
              {
                  name: sel
                  desc: "Port selection index for pad pad_gpioa18."
                  bits: "5:0"
                  enum: [
                      { value: "0", name: "register", desc: "Connects the Pad to the internal configuration register."}
                      { value: "1", name: "port_dvsi0_are", desc: "Connect port are from port group dvsi0 to this pad." }
                      { value: "2", name: "port_dvsi0_asa", desc: "Connect port asa from port group dvsi0 to this pad." }
                      { value: "3", name: "port_dvsi0_asy", desc: "Connect port asy from port group dvsi0 to this pad." }
                      { value: "4", name: "port_dvsi0_cfg0", desc: "Connect port cfg0 from port group dvsi0 to this pad." }
                      { value: "5", name: "port_dvsi0_cfg1", desc: "Connect port cfg1 from port group dvsi0 to this pad." }
                      { value: "6", name: "port_dvsi0_cfg2", desc: "Connect port cfg2 from port group dvsi0 to this pad." }
                      { value: "7", name: "port_dvsi0_cfg3", desc: "Connect port cfg3 from port group dvsi0 to this pad." }
                      { value: "8", name: "port_dvsi0_cfg4", desc: "Connect port cfg4 from port group dvsi0 to this pad." }
                      { value: "9", name: "port_dvsi0_cfg5", desc: "Connect port cfg5 from port group dvsi0 to this pad." }
                      { value: "10", name: "port_dvsi0_cfg6", desc: "Connect port cfg6 from port group dvsi0 to this pad." }
                      { value: "11", name: "port_dvsi0_cfg7", desc: "Connect port cfg7 from port group dvsi0 to this pad." }
                      { value: "12", name: "port_dvsi0_off0", desc: "Connect port off0 from port group dvsi0 to this pad." }
                      { value: "13", name: "port_dvsi0_off1", desc: "Connect port off1 from port group dvsi0 to this pad." }
                      { value: "14", name: "port_dvsi0_off2", desc: "Connect port off2 from port group dvsi0 to this pad." }
                      { value: "15", name: "port_dvsi0_off3", desc: "Connect port off3 from port group dvsi0 to this pad." }
                      { value: "16", name: "port_dvsi0_on0", desc: "Connect port on0 from port group dvsi0 to this pad." }
                      { value: "17", name: "port_dvsi0_on1", desc: "Connect port on1 from port group dvsi0 to this pad." }
                      { value: "18", name: "port_dvsi0_on2", desc: "Connect port on2 from port group dvsi0 to this pad." }
                      { value: "19", name: "port_dvsi0_on3", desc: "Connect port on3 from port group dvsi0 to this pad." }
                      { value: "20", name: "port_dvsi0_sxy", desc: "Connect port sxy from port group dvsi0 to this pad." }
                      { value: "21", name: "port_dvsi0_xclk", desc: "Connect port xclk from port group dvsi0 to this pad." }
                      { value: "22", name: "port_dvsi0_xnrst", desc: "Connect port xnrst from port group dvsi0 to this pad." }
                      { value: "23", name: "port_dvsi0_xydata0", desc: "Connect port xydata0 from port group dvsi0 to this pad." }
                      { value: "24", name: "port_dvsi0_xydata1", desc: "Connect port xydata1 from port group dvsi0 to this pad." }
                      { value: "25", name: "port_dvsi0_xydata2", desc: "Connect port xydata2 from port group dvsi0 to this pad." }
                      { value: "26", name: "port_dvsi0_xydata3", desc: "Connect port xydata3 from port group dvsi0 to this pad." }
                      { value: "27", name: "port_dvsi0_xydata4", desc: "Connect port xydata4 from port group dvsi0 to this pad." }
                      { value: "28", name: "port_dvsi0_xydata5", desc: "Connect port xydata5 from port group dvsi0 to this pad." }
                      { value: "29", name: "port_dvsi0_xydata6", desc: "Connect port xydata6 from port group dvsi0 to this pad." }
                      { value: "30", name: "port_dvsi0_xydata7", desc: "Connect port xydata7 from port group dvsi0 to this pad." }
                      { value: "31", name: "port_dvsi0_yclk", desc: "Connect port yclk from port group dvsi0 to this pad." }
                      { value: "32", name: "port_dvsi0_ynrst", desc: "Connect port ynrst from port group dvsi0 to this pad." }
                      { value: "33", name: "port_gpio_a_gpio18", desc: "Connect port gpio18 from port group gpio_a to this pad." }
                      { value: "34", name: "port_i2c0_i2c_scl", desc: "Connect port i2c_scl from port group i2c0 to this pad." }
                      { value: "35", name: "port_i2c0_i2c_sda", desc: "Connect port i2c_sda from port group i2c0 to this pad." }
                      { value: "36", name: "port_i2c1_i2c_scl", desc: "Connect port i2c_scl from port group i2c1 to this pad." }
                      { value: "37", name: "port_i2c1_i2c_sda", desc: "Connect port i2c_sda from port group i2c1 to this pad." }
                      { value: "38", name: "port_i2c2_i2c_scl", desc: "Connect port i2c_scl from port group i2c2 to this pad." }
                      { value: "39", name: "port_i2c2_i2c_sda", desc: "Connect port i2c_sda from port group i2c2 to this pad." }
                      { value: "40", name: "port_i2c3_i2c_scl", desc: "Connect port i2c_scl from port group i2c3 to this pad." }
                      { value: "41", name: "port_i2c3_i2c_sda", desc: "Connect port i2c_sda from port group i2c3 to this pad." }
                      { value: "42", name: "port_uart0_rx", desc: "Connect port rx from port group uart0 to this pad." }
                      { value: "43", name: "port_uart0_tx", desc: "Connect port tx from port group uart0 to this pad." }
                      { value: "44", name: "port_uart1_rx", desc: "Connect port rx from port group uart1 to this pad." }
                      { value: "45", name: "port_uart1_tx", desc: "Connect port tx from port group uart1 to this pad." }
                  ]
              }
          ]
      }

      {
          name: PAD_GPIOA19_CFG
          desc: '''
            Pad signal configuration.
          '''
          swaccess: "rw"
          fields: [
            {
                bits: "0"
                name: chip2pad
                desc: '''
                     The signal that connects to the pads TX driver
                '''
                swaccess: "rw"
                hwaccess: "hro"
                resval: "0"
            },
            {
                bits: "2:1"
                name: drv
                desc: '''
                     Driving strength selector
                '''
                swaccess: "rw"
                hwaccess: "hro"
                resval: "3"
            },
            {
                bits: "3"
                name: pde
                desc: '''
                     Pull down resistor enable
                '''
                swaccess: "rw"
                hwaccess: "hro"
                resval: "0"
            },
            {
                bits: "4"
                name: pue
                desc: '''
                     Pull up resistor enable
                '''
                swaccess: "rw"
                hwaccess: "hro"
                resval: "0"
            },
            {
                bits: "5"
                name: rxe
                desc: '''
                     Active high RX driver enable 
                '''
                swaccess: "rw"
                hwaccess: "hro"
                resval: "1"
            },
            {
                bits: "6"
                name: slw
                desc: '''
                     
                '''
                swaccess: "rw"
                hwaccess: "hro"
                resval: "0"
            },
            {
                bits: "7"
                name: smt
                desc: '''
                     Schmit trigger enable
                '''
                swaccess: "rw"
                hwaccess: "hro"
                resval: "0"
            },
            {
                bits: "8"
                name: trie
                desc: '''
                      Active high tri-state enable (active low TX driver enable)
                '''
                swaccess: "rw"
                hwaccess: "hro"
                resval: "1"
            },
          ]
      }

       {
          name: PAD_GPIOA19_MUX_SEL
          desc: '''
              Pad signal port multiplex selection for pad pad_gpioa19. The programmed value defines which port
              is connected to the pad.
          '''
          swaccess: "rw"
          hwaccess: "hro"
          resval: 0
          fields: [
              {
                  name: sel
                  desc: "Port selection index for pad pad_gpioa19."
                  bits: "5:0"
                  enum: [
                      { value: "0", name: "register", desc: "Connects the Pad to the internal configuration register."}
                      { value: "1", name: "port_dvsi0_are", desc: "Connect port are from port group dvsi0 to this pad." }
                      { value: "2", name: "port_dvsi0_asa", desc: "Connect port asa from port group dvsi0 to this pad." }
                      { value: "3", name: "port_dvsi0_asy", desc: "Connect port asy from port group dvsi0 to this pad." }
                      { value: "4", name: "port_dvsi0_cfg0", desc: "Connect port cfg0 from port group dvsi0 to this pad." }
                      { value: "5", name: "port_dvsi0_cfg1", desc: "Connect port cfg1 from port group dvsi0 to this pad." }
                      { value: "6", name: "port_dvsi0_cfg2", desc: "Connect port cfg2 from port group dvsi0 to this pad." }
                      { value: "7", name: "port_dvsi0_cfg3", desc: "Connect port cfg3 from port group dvsi0 to this pad." }
                      { value: "8", name: "port_dvsi0_cfg4", desc: "Connect port cfg4 from port group dvsi0 to this pad." }
                      { value: "9", name: "port_dvsi0_cfg5", desc: "Connect port cfg5 from port group dvsi0 to this pad." }
                      { value: "10", name: "port_dvsi0_cfg6", desc: "Connect port cfg6 from port group dvsi0 to this pad." }
                      { value: "11", name: "port_dvsi0_cfg7", desc: "Connect port cfg7 from port group dvsi0 to this pad." }
                      { value: "12", name: "port_dvsi0_off0", desc: "Connect port off0 from port group dvsi0 to this pad." }
                      { value: "13", name: "port_dvsi0_off1", desc: "Connect port off1 from port group dvsi0 to this pad." }
                      { value: "14", name: "port_dvsi0_off2", desc: "Connect port off2 from port group dvsi0 to this pad." }
                      { value: "15", name: "port_dvsi0_off3", desc: "Connect port off3 from port group dvsi0 to this pad." }
                      { value: "16", name: "port_dvsi0_on0", desc: "Connect port on0 from port group dvsi0 to this pad." }
                      { value: "17", name: "port_dvsi0_on1", desc: "Connect port on1 from port group dvsi0 to this pad." }
                      { value: "18", name: "port_dvsi0_on2", desc: "Connect port on2 from port group dvsi0 to this pad." }
                      { value: "19", name: "port_dvsi0_on3", desc: "Connect port on3 from port group dvsi0 to this pad." }
                      { value: "20", name: "port_dvsi0_sxy", desc: "Connect port sxy from port group dvsi0 to this pad." }
                      { value: "21", name: "port_dvsi0_xclk", desc: "Connect port xclk from port group dvsi0 to this pad." }
                      { value: "22", name: "port_dvsi0_xnrst", desc: "Connect port xnrst from port group dvsi0 to this pad." }
                      { value: "23", name: "port_dvsi0_xydata0", desc: "Connect port xydata0 from port group dvsi0 to this pad." }
                      { value: "24", name: "port_dvsi0_xydata1", desc: "Connect port xydata1 from port group dvsi0 to this pad." }
                      { value: "25", name: "port_dvsi0_xydata2", desc: "Connect port xydata2 from port group dvsi0 to this pad." }
                      { value: "26", name: "port_dvsi0_xydata3", desc: "Connect port xydata3 from port group dvsi0 to this pad." }
                      { value: "27", name: "port_dvsi0_xydata4", desc: "Connect port xydata4 from port group dvsi0 to this pad." }
                      { value: "28", name: "port_dvsi0_xydata5", desc: "Connect port xydata5 from port group dvsi0 to this pad." }
                      { value: "29", name: "port_dvsi0_xydata6", desc: "Connect port xydata6 from port group dvsi0 to this pad." }
                      { value: "30", name: "port_dvsi0_xydata7", desc: "Connect port xydata7 from port group dvsi0 to this pad." }
                      { value: "31", name: "port_dvsi0_yclk", desc: "Connect port yclk from port group dvsi0 to this pad." }
                      { value: "32", name: "port_dvsi0_ynrst", desc: "Connect port ynrst from port group dvsi0 to this pad." }
                      { value: "33", name: "port_gpio_a_gpio19", desc: "Connect port gpio19 from port group gpio_a to this pad." }
                      { value: "34", name: "port_i2c0_i2c_scl", desc: "Connect port i2c_scl from port group i2c0 to this pad." }
                      { value: "35", name: "port_i2c0_i2c_sda", desc: "Connect port i2c_sda from port group i2c0 to this pad." }
                      { value: "36", name: "port_i2c1_i2c_scl", desc: "Connect port i2c_scl from port group i2c1 to this pad." }
                      { value: "37", name: "port_i2c1_i2c_sda", desc: "Connect port i2c_sda from port group i2c1 to this pad." }
                      { value: "38", name: "port_i2c2_i2c_scl", desc: "Connect port i2c_scl from port group i2c2 to this pad." }
                      { value: "39", name: "port_i2c2_i2c_sda", desc: "Connect port i2c_sda from port group i2c2 to this pad." }
                      { value: "40", name: "port_i2c3_i2c_scl", desc: "Connect port i2c_scl from port group i2c3 to this pad." }
                      { value: "41", name: "port_i2c3_i2c_sda", desc: "Connect port i2c_sda from port group i2c3 to this pad." }
                      { value: "42", name: "port_uart0_rx", desc: "Connect port rx from port group uart0 to this pad." }
                      { value: "43", name: "port_uart0_tx", desc: "Connect port tx from port group uart0 to this pad." }
                      { value: "44", name: "port_uart1_rx", desc: "Connect port rx from port group uart1 to this pad." }
                      { value: "45", name: "port_uart1_tx", desc: "Connect port tx from port group uart1 to this pad." }
                  ]
              }
          ]
      }

      {
          name: PAD_GPIOA20_CFG
          desc: '''
            Pad signal configuration.
          '''
          swaccess: "rw"
          fields: [
            {
                bits: "0"
                name: chip2pad
                desc: '''
                     The signal that connects to the pads TX driver
                '''
                swaccess: "rw"
                hwaccess: "hro"
                resval: "0"
            },
            {
                bits: "2:1"
                name: drv
                desc: '''
                     Driving strength selector
                '''
                swaccess: "rw"
                hwaccess: "hro"
                resval: "3"
            },
            {
                bits: "3"
                name: pde
                desc: '''
                     Pull down resistor enable
                '''
                swaccess: "rw"
                hwaccess: "hro"
                resval: "0"
            },
            {
                bits: "4"
                name: pue
                desc: '''
                     Pull up resistor enable
                '''
                swaccess: "rw"
                hwaccess: "hro"
                resval: "0"
            },
            {
                bits: "5"
                name: rxe
                desc: '''
                     Active high RX driver enable 
                '''
                swaccess: "rw"
                hwaccess: "hro"
                resval: "1"
            },
            {
                bits: "6"
                name: slw
                desc: '''
                     
                '''
                swaccess: "rw"
                hwaccess: "hro"
                resval: "0"
            },
            {
                bits: "7"
                name: smt
                desc: '''
                     Schmit trigger enable
                '''
                swaccess: "rw"
                hwaccess: "hro"
                resval: "0"
            },
            {
                bits: "8"
                name: trie
                desc: '''
                      Active high tri-state enable (active low TX driver enable)
                '''
                swaccess: "rw"
                hwaccess: "hro"
                resval: "1"
            },
          ]
      }

       {
          name: PAD_GPIOA20_MUX_SEL
          desc: '''
              Pad signal port multiplex selection for pad pad_gpioa20. The programmed value defines which port
              is connected to the pad.
          '''
          swaccess: "rw"
          hwaccess: "hro"
          resval: 0
          fields: [
              {
                  name: sel
                  desc: "Port selection index for pad pad_gpioa20."
                  bits: "5:0"
                  enum: [
                      { value: "0", name: "register", desc: "Connects the Pad to the internal configuration register."}
                      { value: "1", name: "port_dvsi0_are", desc: "Connect port are from port group dvsi0 to this pad." }
                      { value: "2", name: "port_dvsi0_asa", desc: "Connect port asa from port group dvsi0 to this pad." }
                      { value: "3", name: "port_dvsi0_asy", desc: "Connect port asy from port group dvsi0 to this pad." }
                      { value: "4", name: "port_dvsi0_cfg0", desc: "Connect port cfg0 from port group dvsi0 to this pad." }
                      { value: "5", name: "port_dvsi0_cfg1", desc: "Connect port cfg1 from port group dvsi0 to this pad." }
                      { value: "6", name: "port_dvsi0_cfg2", desc: "Connect port cfg2 from port group dvsi0 to this pad." }
                      { value: "7", name: "port_dvsi0_cfg3", desc: "Connect port cfg3 from port group dvsi0 to this pad." }
                      { value: "8", name: "port_dvsi0_cfg4", desc: "Connect port cfg4 from port group dvsi0 to this pad." }
                      { value: "9", name: "port_dvsi0_cfg5", desc: "Connect port cfg5 from port group dvsi0 to this pad." }
                      { value: "10", name: "port_dvsi0_cfg6", desc: "Connect port cfg6 from port group dvsi0 to this pad." }
                      { value: "11", name: "port_dvsi0_cfg7", desc: "Connect port cfg7 from port group dvsi0 to this pad." }
                      { value: "12", name: "port_dvsi0_off0", desc: "Connect port off0 from port group dvsi0 to this pad." }
                      { value: "13", name: "port_dvsi0_off1", desc: "Connect port off1 from port group dvsi0 to this pad." }
                      { value: "14", name: "port_dvsi0_off2", desc: "Connect port off2 from port group dvsi0 to this pad." }
                      { value: "15", name: "port_dvsi0_off3", desc: "Connect port off3 from port group dvsi0 to this pad." }
                      { value: "16", name: "port_dvsi0_on0", desc: "Connect port on0 from port group dvsi0 to this pad." }
                      { value: "17", name: "port_dvsi0_on1", desc: "Connect port on1 from port group dvsi0 to this pad." }
                      { value: "18", name: "port_dvsi0_on2", desc: "Connect port on2 from port group dvsi0 to this pad." }
                      { value: "19", name: "port_dvsi0_on3", desc: "Connect port on3 from port group dvsi0 to this pad." }
                      { value: "20", name: "port_dvsi0_sxy", desc: "Connect port sxy from port group dvsi0 to this pad." }
                      { value: "21", name: "port_dvsi0_xclk", desc: "Connect port xclk from port group dvsi0 to this pad." }
                      { value: "22", name: "port_dvsi0_xnrst", desc: "Connect port xnrst from port group dvsi0 to this pad." }
                      { value: "23", name: "port_dvsi0_xydata0", desc: "Connect port xydata0 from port group dvsi0 to this pad." }
                      { value: "24", name: "port_dvsi0_xydata1", desc: "Connect port xydata1 from port group dvsi0 to this pad." }
                      { value: "25", name: "port_dvsi0_xydata2", desc: "Connect port xydata2 from port group dvsi0 to this pad." }
                      { value: "26", name: "port_dvsi0_xydata3", desc: "Connect port xydata3 from port group dvsi0 to this pad." }
                      { value: "27", name: "port_dvsi0_xydata4", desc: "Connect port xydata4 from port group dvsi0 to this pad." }
                      { value: "28", name: "port_dvsi0_xydata5", desc: "Connect port xydata5 from port group dvsi0 to this pad." }
                      { value: "29", name: "port_dvsi0_xydata6", desc: "Connect port xydata6 from port group dvsi0 to this pad." }
                      { value: "30", name: "port_dvsi0_xydata7", desc: "Connect port xydata7 from port group dvsi0 to this pad." }
                      { value: "31", name: "port_dvsi0_yclk", desc: "Connect port yclk from port group dvsi0 to this pad." }
                      { value: "32", name: "port_dvsi0_ynrst", desc: "Connect port ynrst from port group dvsi0 to this pad." }
                      { value: "33", name: "port_gpio_a_gpio20", desc: "Connect port gpio20 from port group gpio_a to this pad." }
                      { value: "34", name: "port_i2c0_i2c_scl", desc: "Connect port i2c_scl from port group i2c0 to this pad." }
                      { value: "35", name: "port_i2c0_i2c_sda", desc: "Connect port i2c_sda from port group i2c0 to this pad." }
                      { value: "36", name: "port_i2c1_i2c_scl", desc: "Connect port i2c_scl from port group i2c1 to this pad." }
                      { value: "37", name: "port_i2c1_i2c_sda", desc: "Connect port i2c_sda from port group i2c1 to this pad." }
                      { value: "38", name: "port_i2c2_i2c_scl", desc: "Connect port i2c_scl from port group i2c2 to this pad." }
                      { value: "39", name: "port_i2c2_i2c_sda", desc: "Connect port i2c_sda from port group i2c2 to this pad." }
                      { value: "40", name: "port_i2c3_i2c_scl", desc: "Connect port i2c_scl from port group i2c3 to this pad." }
                      { value: "41", name: "port_i2c3_i2c_sda", desc: "Connect port i2c_sda from port group i2c3 to this pad." }
                      { value: "42", name: "port_uart0_rx", desc: "Connect port rx from port group uart0 to this pad." }
                      { value: "43", name: "port_uart0_tx", desc: "Connect port tx from port group uart0 to this pad." }
                      { value: "44", name: "port_uart1_rx", desc: "Connect port rx from port group uart1 to this pad." }
                      { value: "45", name: "port_uart1_tx", desc: "Connect port tx from port group uart1 to this pad." }
                  ]
              }
          ]
      }

      {
          name: PAD_GPIOA21_CFG
          desc: '''
            Pad signal configuration.
          '''
          swaccess: "rw"
          fields: [
            {
                bits: "0"
                name: chip2pad
                desc: '''
                     The signal that connects to the pads TX driver
                '''
                swaccess: "rw"
                hwaccess: "hro"
                resval: "0"
            },
            {
                bits: "2:1"
                name: drv
                desc: '''
                     Driving strength selector
                '''
                swaccess: "rw"
                hwaccess: "hro"
                resval: "3"
            },
            {
                bits: "3"
                name: pde
                desc: '''
                     Pull down resistor enable
                '''
                swaccess: "rw"
                hwaccess: "hro"
                resval: "0"
            },
            {
                bits: "4"
                name: pue
                desc: '''
                     Pull up resistor enable
                '''
                swaccess: "rw"
                hwaccess: "hro"
                resval: "0"
            },
            {
                bits: "5"
                name: rxe
                desc: '''
                     Active high RX driver enable 
                '''
                swaccess: "rw"
                hwaccess: "hro"
                resval: "1"
            },
            {
                bits: "6"
                name: slw
                desc: '''
                     
                '''
                swaccess: "rw"
                hwaccess: "hro"
                resval: "0"
            },
            {
                bits: "7"
                name: smt
                desc: '''
                     Schmit trigger enable
                '''
                swaccess: "rw"
                hwaccess: "hro"
                resval: "0"
            },
            {
                bits: "8"
                name: trie
                desc: '''
                      Active high tri-state enable (active low TX driver enable)
                '''
                swaccess: "rw"
                hwaccess: "hro"
                resval: "1"
            },
          ]
      }

       {
          name: PAD_GPIOA21_MUX_SEL
          desc: '''
              Pad signal port multiplex selection for pad pad_gpioa21. The programmed value defines which port
              is connected to the pad.
          '''
          swaccess: "rw"
          hwaccess: "hro"
          resval: 0
          fields: [
              {
                  name: sel
                  desc: "Port selection index for pad pad_gpioa21."
                  bits: "5:0"
                  enum: [
                      { value: "0", name: "register", desc: "Connects the Pad to the internal configuration register."}
                      { value: "1", name: "port_dvsi0_are", desc: "Connect port are from port group dvsi0 to this pad." }
                      { value: "2", name: "port_dvsi0_asa", desc: "Connect port asa from port group dvsi0 to this pad." }
                      { value: "3", name: "port_dvsi0_asy", desc: "Connect port asy from port group dvsi0 to this pad." }
                      { value: "4", name: "port_dvsi0_cfg0", desc: "Connect port cfg0 from port group dvsi0 to this pad." }
                      { value: "5", name: "port_dvsi0_cfg1", desc: "Connect port cfg1 from port group dvsi0 to this pad." }
                      { value: "6", name: "port_dvsi0_cfg2", desc: "Connect port cfg2 from port group dvsi0 to this pad." }
                      { value: "7", name: "port_dvsi0_cfg3", desc: "Connect port cfg3 from port group dvsi0 to this pad." }
                      { value: "8", name: "port_dvsi0_cfg4", desc: "Connect port cfg4 from port group dvsi0 to this pad." }
                      { value: "9", name: "port_dvsi0_cfg5", desc: "Connect port cfg5 from port group dvsi0 to this pad." }
                      { value: "10", name: "port_dvsi0_cfg6", desc: "Connect port cfg6 from port group dvsi0 to this pad." }
                      { value: "11", name: "port_dvsi0_cfg7", desc: "Connect port cfg7 from port group dvsi0 to this pad." }
                      { value: "12", name: "port_dvsi0_off0", desc: "Connect port off0 from port group dvsi0 to this pad." }
                      { value: "13", name: "port_dvsi0_off1", desc: "Connect port off1 from port group dvsi0 to this pad." }
                      { value: "14", name: "port_dvsi0_off2", desc: "Connect port off2 from port group dvsi0 to this pad." }
                      { value: "15", name: "port_dvsi0_off3", desc: "Connect port off3 from port group dvsi0 to this pad." }
                      { value: "16", name: "port_dvsi0_on0", desc: "Connect port on0 from port group dvsi0 to this pad." }
                      { value: "17", name: "port_dvsi0_on1", desc: "Connect port on1 from port group dvsi0 to this pad." }
                      { value: "18", name: "port_dvsi0_on2", desc: "Connect port on2 from port group dvsi0 to this pad." }
                      { value: "19", name: "port_dvsi0_on3", desc: "Connect port on3 from port group dvsi0 to this pad." }
                      { value: "20", name: "port_dvsi0_sxy", desc: "Connect port sxy from port group dvsi0 to this pad." }
                      { value: "21", name: "port_dvsi0_xclk", desc: "Connect port xclk from port group dvsi0 to this pad." }
                      { value: "22", name: "port_dvsi0_xnrst", desc: "Connect port xnrst from port group dvsi0 to this pad." }
                      { value: "23", name: "port_dvsi0_xydata0", desc: "Connect port xydata0 from port group dvsi0 to this pad." }
                      { value: "24", name: "port_dvsi0_xydata1", desc: "Connect port xydata1 from port group dvsi0 to this pad." }
                      { value: "25", name: "port_dvsi0_xydata2", desc: "Connect port xydata2 from port group dvsi0 to this pad." }
                      { value: "26", name: "port_dvsi0_xydata3", desc: "Connect port xydata3 from port group dvsi0 to this pad." }
                      { value: "27", name: "port_dvsi0_xydata4", desc: "Connect port xydata4 from port group dvsi0 to this pad." }
                      { value: "28", name: "port_dvsi0_xydata5", desc: "Connect port xydata5 from port group dvsi0 to this pad." }
                      { value: "29", name: "port_dvsi0_xydata6", desc: "Connect port xydata6 from port group dvsi0 to this pad." }
                      { value: "30", name: "port_dvsi0_xydata7", desc: "Connect port xydata7 from port group dvsi0 to this pad." }
                      { value: "31", name: "port_dvsi0_yclk", desc: "Connect port yclk from port group dvsi0 to this pad." }
                      { value: "32", name: "port_dvsi0_ynrst", desc: "Connect port ynrst from port group dvsi0 to this pad." }
                      { value: "33", name: "port_gpio_a_gpio21", desc: "Connect port gpio21 from port group gpio_a to this pad." }
                      { value: "34", name: "port_i2c0_i2c_scl", desc: "Connect port i2c_scl from port group i2c0 to this pad." }
                      { value: "35", name: "port_i2c0_i2c_sda", desc: "Connect port i2c_sda from port group i2c0 to this pad." }
                      { value: "36", name: "port_i2c1_i2c_scl", desc: "Connect port i2c_scl from port group i2c1 to this pad." }
                      { value: "37", name: "port_i2c1_i2c_sda", desc: "Connect port i2c_sda from port group i2c1 to this pad." }
                      { value: "38", name: "port_i2c2_i2c_scl", desc: "Connect port i2c_scl from port group i2c2 to this pad." }
                      { value: "39", name: "port_i2c2_i2c_sda", desc: "Connect port i2c_sda from port group i2c2 to this pad." }
                      { value: "40", name: "port_i2c3_i2c_scl", desc: "Connect port i2c_scl from port group i2c3 to this pad." }
                      { value: "41", name: "port_i2c3_i2c_sda", desc: "Connect port i2c_sda from port group i2c3 to this pad." }
                      { value: "42", name: "port_uart0_rx", desc: "Connect port rx from port group uart0 to this pad." }
                      { value: "43", name: "port_uart0_tx", desc: "Connect port tx from port group uart0 to this pad." }
                      { value: "44", name: "port_uart1_rx", desc: "Connect port rx from port group uart1 to this pad." }
                      { value: "45", name: "port_uart1_tx", desc: "Connect port tx from port group uart1 to this pad." }
                  ]
              }
          ]
      }

      {
          name: PAD_GPIOA22_CFG
          desc: '''
            Pad signal configuration.
          '''
          swaccess: "rw"
          fields: [
            {
                bits: "0"
                name: chip2pad
                desc: '''
                     The signal that connects to the pads TX driver
                '''
                swaccess: "rw"
                hwaccess: "hro"
                resval: "0"
            },
            {
                bits: "2:1"
                name: drv
                desc: '''
                     Driving strength selector
                '''
                swaccess: "rw"
                hwaccess: "hro"
                resval: "3"
            },
            {
                bits: "3"
                name: pde
                desc: '''
                     Pull down resistor enable
                '''
                swaccess: "rw"
                hwaccess: "hro"
                resval: "0"
            },
            {
                bits: "4"
                name: pue
                desc: '''
                     Pull up resistor enable
                '''
                swaccess: "rw"
                hwaccess: "hro"
                resval: "0"
            },
            {
                bits: "5"
                name: rxe
                desc: '''
                     Active high RX driver enable 
                '''
                swaccess: "rw"
                hwaccess: "hro"
                resval: "1"
            },
            {
                bits: "6"
                name: slw
                desc: '''
                     
                '''
                swaccess: "rw"
                hwaccess: "hro"
                resval: "0"
            },
            {
                bits: "7"
                name: smt
                desc: '''
                     Schmit trigger enable
                '''
                swaccess: "rw"
                hwaccess: "hro"
                resval: "0"
            },
            {
                bits: "8"
                name: trie
                desc: '''
                      Active high tri-state enable (active low TX driver enable)
                '''
                swaccess: "rw"
                hwaccess: "hro"
                resval: "1"
            },
          ]
      }

       {
          name: PAD_GPIOA22_MUX_SEL
          desc: '''
              Pad signal port multiplex selection for pad pad_gpioa22. The programmed value defines which port
              is connected to the pad.
          '''
          swaccess: "rw"
          hwaccess: "hro"
          resval: 0
          fields: [
              {
                  name: sel
                  desc: "Port selection index for pad pad_gpioa22."
                  bits: "5:0"
                  enum: [
                      { value: "0", name: "register", desc: "Connects the Pad to the internal configuration register."}
                      { value: "1", name: "port_dvsi0_are", desc: "Connect port are from port group dvsi0 to this pad." }
                      { value: "2", name: "port_dvsi0_asa", desc: "Connect port asa from port group dvsi0 to this pad." }
                      { value: "3", name: "port_dvsi0_asy", desc: "Connect port asy from port group dvsi0 to this pad." }
                      { value: "4", name: "port_dvsi0_cfg0", desc: "Connect port cfg0 from port group dvsi0 to this pad." }
                      { value: "5", name: "port_dvsi0_cfg1", desc: "Connect port cfg1 from port group dvsi0 to this pad." }
                      { value: "6", name: "port_dvsi0_cfg2", desc: "Connect port cfg2 from port group dvsi0 to this pad." }
                      { value: "7", name: "port_dvsi0_cfg3", desc: "Connect port cfg3 from port group dvsi0 to this pad." }
                      { value: "8", name: "port_dvsi0_cfg4", desc: "Connect port cfg4 from port group dvsi0 to this pad." }
                      { value: "9", name: "port_dvsi0_cfg5", desc: "Connect port cfg5 from port group dvsi0 to this pad." }
                      { value: "10", name: "port_dvsi0_cfg6", desc: "Connect port cfg6 from port group dvsi0 to this pad." }
                      { value: "11", name: "port_dvsi0_cfg7", desc: "Connect port cfg7 from port group dvsi0 to this pad." }
                      { value: "12", name: "port_dvsi0_off0", desc: "Connect port off0 from port group dvsi0 to this pad." }
                      { value: "13", name: "port_dvsi0_off1", desc: "Connect port off1 from port group dvsi0 to this pad." }
                      { value: "14", name: "port_dvsi0_off2", desc: "Connect port off2 from port group dvsi0 to this pad." }
                      { value: "15", name: "port_dvsi0_off3", desc: "Connect port off3 from port group dvsi0 to this pad." }
                      { value: "16", name: "port_dvsi0_on0", desc: "Connect port on0 from port group dvsi0 to this pad." }
                      { value: "17", name: "port_dvsi0_on1", desc: "Connect port on1 from port group dvsi0 to this pad." }
                      { value: "18", name: "port_dvsi0_on2", desc: "Connect port on2 from port group dvsi0 to this pad." }
                      { value: "19", name: "port_dvsi0_on3", desc: "Connect port on3 from port group dvsi0 to this pad." }
                      { value: "20", name: "port_dvsi0_sxy", desc: "Connect port sxy from port group dvsi0 to this pad." }
                      { value: "21", name: "port_dvsi0_xclk", desc: "Connect port xclk from port group dvsi0 to this pad." }
                      { value: "22", name: "port_dvsi0_xnrst", desc: "Connect port xnrst from port group dvsi0 to this pad." }
                      { value: "23", name: "port_dvsi0_xydata0", desc: "Connect port xydata0 from port group dvsi0 to this pad." }
                      { value: "24", name: "port_dvsi0_xydata1", desc: "Connect port xydata1 from port group dvsi0 to this pad." }
                      { value: "25", name: "port_dvsi0_xydata2", desc: "Connect port xydata2 from port group dvsi0 to this pad." }
                      { value: "26", name: "port_dvsi0_xydata3", desc: "Connect port xydata3 from port group dvsi0 to this pad." }
                      { value: "27", name: "port_dvsi0_xydata4", desc: "Connect port xydata4 from port group dvsi0 to this pad." }
                      { value: "28", name: "port_dvsi0_xydata5", desc: "Connect port xydata5 from port group dvsi0 to this pad." }
                      { value: "29", name: "port_dvsi0_xydata6", desc: "Connect port xydata6 from port group dvsi0 to this pad." }
                      { value: "30", name: "port_dvsi0_xydata7", desc: "Connect port xydata7 from port group dvsi0 to this pad." }
                      { value: "31", name: "port_dvsi0_yclk", desc: "Connect port yclk from port group dvsi0 to this pad." }
                      { value: "32", name: "port_dvsi0_ynrst", desc: "Connect port ynrst from port group dvsi0 to this pad." }
                      { value: "33", name: "port_gpio_a_gpio22", desc: "Connect port gpio22 from port group gpio_a to this pad." }
                      { value: "34", name: "port_i2c0_i2c_scl", desc: "Connect port i2c_scl from port group i2c0 to this pad." }
                      { value: "35", name: "port_i2c0_i2c_sda", desc: "Connect port i2c_sda from port group i2c0 to this pad." }
                      { value: "36", name: "port_i2c1_i2c_scl", desc: "Connect port i2c_scl from port group i2c1 to this pad." }
                      { value: "37", name: "port_i2c1_i2c_sda", desc: "Connect port i2c_sda from port group i2c1 to this pad." }
                      { value: "38", name: "port_i2c2_i2c_scl", desc: "Connect port i2c_scl from port group i2c2 to this pad." }
                      { value: "39", name: "port_i2c2_i2c_sda", desc: "Connect port i2c_sda from port group i2c2 to this pad." }
                      { value: "40", name: "port_i2c3_i2c_scl", desc: "Connect port i2c_scl from port group i2c3 to this pad." }
                      { value: "41", name: "port_i2c3_i2c_sda", desc: "Connect port i2c_sda from port group i2c3 to this pad." }
                      { value: "42", name: "port_uart0_rx", desc: "Connect port rx from port group uart0 to this pad." }
                      { value: "43", name: "port_uart0_tx", desc: "Connect port tx from port group uart0 to this pad." }
                      { value: "44", name: "port_uart1_rx", desc: "Connect port rx from port group uart1 to this pad." }
                      { value: "45", name: "port_uart1_tx", desc: "Connect port tx from port group uart1 to this pad." }
                  ]
              }
          ]
      }

      {
          name: PAD_GPIOA23_CFG
          desc: '''
            Pad signal configuration.
          '''
          swaccess: "rw"
          fields: [
            {
                bits: "0"
                name: chip2pad
                desc: '''
                     The signal that connects to the pads TX driver
                '''
                swaccess: "rw"
                hwaccess: "hro"
                resval: "0"
            },
            {
                bits: "2:1"
                name: drv
                desc: '''
                     Driving strength selector
                '''
                swaccess: "rw"
                hwaccess: "hro"
                resval: "3"
            },
            {
                bits: "3"
                name: pde
                desc: '''
                     Pull down resistor enable
                '''
                swaccess: "rw"
                hwaccess: "hro"
                resval: "0"
            },
            {
                bits: "4"
                name: pue
                desc: '''
                     Pull up resistor enable
                '''
                swaccess: "rw"
                hwaccess: "hro"
                resval: "0"
            },
            {
                bits: "5"
                name: rxe
                desc: '''
                     Active high RX driver enable 
                '''
                swaccess: "rw"
                hwaccess: "hro"
                resval: "1"
            },
            {
                bits: "6"
                name: slw
                desc: '''
                     
                '''
                swaccess: "rw"
                hwaccess: "hro"
                resval: "0"
            },
            {
                bits: "7"
                name: smt
                desc: '''
                     Schmit trigger enable
                '''
                swaccess: "rw"
                hwaccess: "hro"
                resval: "0"
            },
            {
                bits: "8"
                name: trie
                desc: '''
                      Active high tri-state enable (active low TX driver enable)
                '''
                swaccess: "rw"
                hwaccess: "hro"
                resval: "1"
            },
          ]
      }

       {
          name: PAD_GPIOA23_MUX_SEL
          desc: '''
              Pad signal port multiplex selection for pad pad_gpioa23. The programmed value defines which port
              is connected to the pad.
          '''
          swaccess: "rw"
          hwaccess: "hro"
          resval: 0
          fields: [
              {
                  name: sel
                  desc: "Port selection index for pad pad_gpioa23."
                  bits: "5:0"
                  enum: [
                      { value: "0", name: "register", desc: "Connects the Pad to the internal configuration register."}
                      { value: "1", name: "port_dvsi0_are", desc: "Connect port are from port group dvsi0 to this pad." }
                      { value: "2", name: "port_dvsi0_asa", desc: "Connect port asa from port group dvsi0 to this pad." }
                      { value: "3", name: "port_dvsi0_asy", desc: "Connect port asy from port group dvsi0 to this pad." }
                      { value: "4", name: "port_dvsi0_cfg0", desc: "Connect port cfg0 from port group dvsi0 to this pad." }
                      { value: "5", name: "port_dvsi0_cfg1", desc: "Connect port cfg1 from port group dvsi0 to this pad." }
                      { value: "6", name: "port_dvsi0_cfg2", desc: "Connect port cfg2 from port group dvsi0 to this pad." }
                      { value: "7", name: "port_dvsi0_cfg3", desc: "Connect port cfg3 from port group dvsi0 to this pad." }
                      { value: "8", name: "port_dvsi0_cfg4", desc: "Connect port cfg4 from port group dvsi0 to this pad." }
                      { value: "9", name: "port_dvsi0_cfg5", desc: "Connect port cfg5 from port group dvsi0 to this pad." }
                      { value: "10", name: "port_dvsi0_cfg6", desc: "Connect port cfg6 from port group dvsi0 to this pad." }
                      { value: "11", name: "port_dvsi0_cfg7", desc: "Connect port cfg7 from port group dvsi0 to this pad." }
                      { value: "12", name: "port_dvsi0_off0", desc: "Connect port off0 from port group dvsi0 to this pad." }
                      { value: "13", name: "port_dvsi0_off1", desc: "Connect port off1 from port group dvsi0 to this pad." }
                      { value: "14", name: "port_dvsi0_off2", desc: "Connect port off2 from port group dvsi0 to this pad." }
                      { value: "15", name: "port_dvsi0_off3", desc: "Connect port off3 from port group dvsi0 to this pad." }
                      { value: "16", name: "port_dvsi0_on0", desc: "Connect port on0 from port group dvsi0 to this pad." }
                      { value: "17", name: "port_dvsi0_on1", desc: "Connect port on1 from port group dvsi0 to this pad." }
                      { value: "18", name: "port_dvsi0_on2", desc: "Connect port on2 from port group dvsi0 to this pad." }
                      { value: "19", name: "port_dvsi0_on3", desc: "Connect port on3 from port group dvsi0 to this pad." }
                      { value: "20", name: "port_dvsi0_sxy", desc: "Connect port sxy from port group dvsi0 to this pad." }
                      { value: "21", name: "port_dvsi0_xclk", desc: "Connect port xclk from port group dvsi0 to this pad." }
                      { value: "22", name: "port_dvsi0_xnrst", desc: "Connect port xnrst from port group dvsi0 to this pad." }
                      { value: "23", name: "port_dvsi0_xydata0", desc: "Connect port xydata0 from port group dvsi0 to this pad." }
                      { value: "24", name: "port_dvsi0_xydata1", desc: "Connect port xydata1 from port group dvsi0 to this pad." }
                      { value: "25", name: "port_dvsi0_xydata2", desc: "Connect port xydata2 from port group dvsi0 to this pad." }
                      { value: "26", name: "port_dvsi0_xydata3", desc: "Connect port xydata3 from port group dvsi0 to this pad." }
                      { value: "27", name: "port_dvsi0_xydata4", desc: "Connect port xydata4 from port group dvsi0 to this pad." }
                      { value: "28", name: "port_dvsi0_xydata5", desc: "Connect port xydata5 from port group dvsi0 to this pad." }
                      { value: "29", name: "port_dvsi0_xydata6", desc: "Connect port xydata6 from port group dvsi0 to this pad." }
                      { value: "30", name: "port_dvsi0_xydata7", desc: "Connect port xydata7 from port group dvsi0 to this pad." }
                      { value: "31", name: "port_dvsi0_yclk", desc: "Connect port yclk from port group dvsi0 to this pad." }
                      { value: "32", name: "port_dvsi0_ynrst", desc: "Connect port ynrst from port group dvsi0 to this pad." }
                      { value: "33", name: "port_gpio_a_gpio23", desc: "Connect port gpio23 from port group gpio_a to this pad." }
                      { value: "34", name: "port_i2c0_i2c_scl", desc: "Connect port i2c_scl from port group i2c0 to this pad." }
                      { value: "35", name: "port_i2c0_i2c_sda", desc: "Connect port i2c_sda from port group i2c0 to this pad." }
                      { value: "36", name: "port_i2c1_i2c_scl", desc: "Connect port i2c_scl from port group i2c1 to this pad." }
                      { value: "37", name: "port_i2c1_i2c_sda", desc: "Connect port i2c_sda from port group i2c1 to this pad." }
                      { value: "38", name: "port_i2c2_i2c_scl", desc: "Connect port i2c_scl from port group i2c2 to this pad." }
                      { value: "39", name: "port_i2c2_i2c_sda", desc: "Connect port i2c_sda from port group i2c2 to this pad." }
                      { value: "40", name: "port_i2c3_i2c_scl", desc: "Connect port i2c_scl from port group i2c3 to this pad." }
                      { value: "41", name: "port_i2c3_i2c_sda", desc: "Connect port i2c_sda from port group i2c3 to this pad." }
                      { value: "42", name: "port_uart0_rx", desc: "Connect port rx from port group uart0 to this pad." }
                      { value: "43", name: "port_uart0_tx", desc: "Connect port tx from port group uart0 to this pad." }
                      { value: "44", name: "port_uart1_rx", desc: "Connect port rx from port group uart1 to this pad." }
                      { value: "45", name: "port_uart1_tx", desc: "Connect port tx from port group uart1 to this pad." }
                  ]
              }
          ]
      }

      {
          name: PAD_GPIOA24_CFG
          desc: '''
            Pad signal configuration.
          '''
          swaccess: "rw"
          fields: [
            {
                bits: "0"
                name: chip2pad
                desc: '''
                     The signal that connects to the pads TX driver
                '''
                swaccess: "rw"
                hwaccess: "hro"
                resval: "0"
            },
            {
                bits: "2:1"
                name: drv
                desc: '''
                     Driving strength selector
                '''
                swaccess: "rw"
                hwaccess: "hro"
                resval: "3"
            },
            {
                bits: "3"
                name: pde
                desc: '''
                     Pull down resistor enable
                '''
                swaccess: "rw"
                hwaccess: "hro"
                resval: "0"
            },
            {
                bits: "4"
                name: pue
                desc: '''
                     Pull up resistor enable
                '''
                swaccess: "rw"
                hwaccess: "hro"
                resval: "0"
            },
            {
                bits: "5"
                name: rxe
                desc: '''
                     Active high RX driver enable 
                '''
                swaccess: "rw"
                hwaccess: "hro"
                resval: "1"
            },
            {
                bits: "6"
                name: slw
                desc: '''
                     
                '''
                swaccess: "rw"
                hwaccess: "hro"
                resval: "0"
            },
            {
                bits: "7"
                name: smt
                desc: '''
                     Schmit trigger enable
                '''
                swaccess: "rw"
                hwaccess: "hro"
                resval: "0"
            },
            {
                bits: "8"
                name: trie
                desc: '''
                      Active high tri-state enable (active low TX driver enable)
                '''
                swaccess: "rw"
                hwaccess: "hro"
                resval: "1"
            },
          ]
      }

       {
          name: PAD_GPIOA24_MUX_SEL
          desc: '''
              Pad signal port multiplex selection for pad pad_gpioa24. The programmed value defines which port
              is connected to the pad.
          '''
          swaccess: "rw"
          hwaccess: "hro"
          resval: 0
          fields: [
              {
                  name: sel
                  desc: "Port selection index for pad pad_gpioa24."
                  bits: "5:0"
                  enum: [
                      { value: "0", name: "register", desc: "Connects the Pad to the internal configuration register."}
                      { value: "1", name: "port_dvsi0_are", desc: "Connect port are from port group dvsi0 to this pad." }
                      { value: "2", name: "port_dvsi0_asa", desc: "Connect port asa from port group dvsi0 to this pad." }
                      { value: "3", name: "port_dvsi0_asy", desc: "Connect port asy from port group dvsi0 to this pad." }
                      { value: "4", name: "port_dvsi0_cfg0", desc: "Connect port cfg0 from port group dvsi0 to this pad." }
                      { value: "5", name: "port_dvsi0_cfg1", desc: "Connect port cfg1 from port group dvsi0 to this pad." }
                      { value: "6", name: "port_dvsi0_cfg2", desc: "Connect port cfg2 from port group dvsi0 to this pad." }
                      { value: "7", name: "port_dvsi0_cfg3", desc: "Connect port cfg3 from port group dvsi0 to this pad." }
                      { value: "8", name: "port_dvsi0_cfg4", desc: "Connect port cfg4 from port group dvsi0 to this pad." }
                      { value: "9", name: "port_dvsi0_cfg5", desc: "Connect port cfg5 from port group dvsi0 to this pad." }
                      { value: "10", name: "port_dvsi0_cfg6", desc: "Connect port cfg6 from port group dvsi0 to this pad." }
                      { value: "11", name: "port_dvsi0_cfg7", desc: "Connect port cfg7 from port group dvsi0 to this pad." }
                      { value: "12", name: "port_dvsi0_off0", desc: "Connect port off0 from port group dvsi0 to this pad." }
                      { value: "13", name: "port_dvsi0_off1", desc: "Connect port off1 from port group dvsi0 to this pad." }
                      { value: "14", name: "port_dvsi0_off2", desc: "Connect port off2 from port group dvsi0 to this pad." }
                      { value: "15", name: "port_dvsi0_off3", desc: "Connect port off3 from port group dvsi0 to this pad." }
                      { value: "16", name: "port_dvsi0_on0", desc: "Connect port on0 from port group dvsi0 to this pad." }
                      { value: "17", name: "port_dvsi0_on1", desc: "Connect port on1 from port group dvsi0 to this pad." }
                      { value: "18", name: "port_dvsi0_on2", desc: "Connect port on2 from port group dvsi0 to this pad." }
                      { value: "19", name: "port_dvsi0_on3", desc: "Connect port on3 from port group dvsi0 to this pad." }
                      { value: "20", name: "port_dvsi0_sxy", desc: "Connect port sxy from port group dvsi0 to this pad." }
                      { value: "21", name: "port_dvsi0_xclk", desc: "Connect port xclk from port group dvsi0 to this pad." }
                      { value: "22", name: "port_dvsi0_xnrst", desc: "Connect port xnrst from port group dvsi0 to this pad." }
                      { value: "23", name: "port_dvsi0_xydata0", desc: "Connect port xydata0 from port group dvsi0 to this pad." }
                      { value: "24", name: "port_dvsi0_xydata1", desc: "Connect port xydata1 from port group dvsi0 to this pad." }
                      { value: "25", name: "port_dvsi0_xydata2", desc: "Connect port xydata2 from port group dvsi0 to this pad." }
                      { value: "26", name: "port_dvsi0_xydata3", desc: "Connect port xydata3 from port group dvsi0 to this pad." }
                      { value: "27", name: "port_dvsi0_xydata4", desc: "Connect port xydata4 from port group dvsi0 to this pad." }
                      { value: "28", name: "port_dvsi0_xydata5", desc: "Connect port xydata5 from port group dvsi0 to this pad." }
                      { value: "29", name: "port_dvsi0_xydata6", desc: "Connect port xydata6 from port group dvsi0 to this pad." }
                      { value: "30", name: "port_dvsi0_xydata7", desc: "Connect port xydata7 from port group dvsi0 to this pad." }
                      { value: "31", name: "port_dvsi0_yclk", desc: "Connect port yclk from port group dvsi0 to this pad." }
                      { value: "32", name: "port_dvsi0_ynrst", desc: "Connect port ynrst from port group dvsi0 to this pad." }
                      { value: "33", name: "port_gpio_a_gpio24", desc: "Connect port gpio24 from port group gpio_a to this pad." }
                      { value: "34", name: "port_i2c0_i2c_scl", desc: "Connect port i2c_scl from port group i2c0 to this pad." }
                      { value: "35", name: "port_i2c0_i2c_sda", desc: "Connect port i2c_sda from port group i2c0 to this pad." }
                      { value: "36", name: "port_i2c1_i2c_scl", desc: "Connect port i2c_scl from port group i2c1 to this pad." }
                      { value: "37", name: "port_i2c1_i2c_sda", desc: "Connect port i2c_sda from port group i2c1 to this pad." }
                      { value: "38", name: "port_i2c2_i2c_scl", desc: "Connect port i2c_scl from port group i2c2 to this pad." }
                      { value: "39", name: "port_i2c2_i2c_sda", desc: "Connect port i2c_sda from port group i2c2 to this pad." }
                      { value: "40", name: "port_i2c3_i2c_scl", desc: "Connect port i2c_scl from port group i2c3 to this pad." }
                      { value: "41", name: "port_i2c3_i2c_sda", desc: "Connect port i2c_sda from port group i2c3 to this pad." }
                      { value: "42", name: "port_uart0_rx", desc: "Connect port rx from port group uart0 to this pad." }
                      { value: "43", name: "port_uart0_tx", desc: "Connect port tx from port group uart0 to this pad." }
                      { value: "44", name: "port_uart1_rx", desc: "Connect port rx from port group uart1 to this pad." }
                      { value: "45", name: "port_uart1_tx", desc: "Connect port tx from port group uart1 to this pad." }
                  ]
              }
          ]
      }

      {
          name: PAD_GPIOA25_CFG
          desc: '''
            Pad signal configuration.
          '''
          swaccess: "rw"
          fields: [
            {
                bits: "0"
                name: chip2pad
                desc: '''
                     The signal that connects to the pads TX driver
                '''
                swaccess: "rw"
                hwaccess: "hro"
                resval: "0"
            },
            {
                bits: "2:1"
                name: drv
                desc: '''
                     Driving strength selector
                '''
                swaccess: "rw"
                hwaccess: "hro"
                resval: "3"
            },
            {
                bits: "3"
                name: pde
                desc: '''
                     Pull down resistor enable
                '''
                swaccess: "rw"
                hwaccess: "hro"
                resval: "0"
            },
            {
                bits: "4"
                name: pue
                desc: '''
                     Pull up resistor enable
                '''
                swaccess: "rw"
                hwaccess: "hro"
                resval: "0"
            },
            {
                bits: "5"
                name: rxe
                desc: '''
                     Active high RX driver enable 
                '''
                swaccess: "rw"
                hwaccess: "hro"
                resval: "1"
            },
            {
                bits: "6"
                name: slw
                desc: '''
                     
                '''
                swaccess: "rw"
                hwaccess: "hro"
                resval: "0"
            },
            {
                bits: "7"
                name: smt
                desc: '''
                     Schmit trigger enable
                '''
                swaccess: "rw"
                hwaccess: "hro"
                resval: "0"
            },
            {
                bits: "8"
                name: trie
                desc: '''
                      Active high tri-state enable (active low TX driver enable)
                '''
                swaccess: "rw"
                hwaccess: "hro"
                resval: "1"
            },
          ]
      }

       {
          name: PAD_GPIOA25_MUX_SEL
          desc: '''
              Pad signal port multiplex selection for pad pad_gpioa25. The programmed value defines which port
              is connected to the pad.
          '''
          swaccess: "rw"
          hwaccess: "hro"
          resval: 0
          fields: [
              {
                  name: sel
                  desc: "Port selection index for pad pad_gpioa25."
                  bits: "5:0"
                  enum: [
                      { value: "0", name: "register", desc: "Connects the Pad to the internal configuration register."}
                      { value: "1", name: "port_dvsi0_are", desc: "Connect port are from port group dvsi0 to this pad." }
                      { value: "2", name: "port_dvsi0_asa", desc: "Connect port asa from port group dvsi0 to this pad." }
                      { value: "3", name: "port_dvsi0_asy", desc: "Connect port asy from port group dvsi0 to this pad." }
                      { value: "4", name: "port_dvsi0_cfg0", desc: "Connect port cfg0 from port group dvsi0 to this pad." }
                      { value: "5", name: "port_dvsi0_cfg1", desc: "Connect port cfg1 from port group dvsi0 to this pad." }
                      { value: "6", name: "port_dvsi0_cfg2", desc: "Connect port cfg2 from port group dvsi0 to this pad." }
                      { value: "7", name: "port_dvsi0_cfg3", desc: "Connect port cfg3 from port group dvsi0 to this pad." }
                      { value: "8", name: "port_dvsi0_cfg4", desc: "Connect port cfg4 from port group dvsi0 to this pad." }
                      { value: "9", name: "port_dvsi0_cfg5", desc: "Connect port cfg5 from port group dvsi0 to this pad." }
                      { value: "10", name: "port_dvsi0_cfg6", desc: "Connect port cfg6 from port group dvsi0 to this pad." }
                      { value: "11", name: "port_dvsi0_cfg7", desc: "Connect port cfg7 from port group dvsi0 to this pad." }
                      { value: "12", name: "port_dvsi0_off0", desc: "Connect port off0 from port group dvsi0 to this pad." }
                      { value: "13", name: "port_dvsi0_off1", desc: "Connect port off1 from port group dvsi0 to this pad." }
                      { value: "14", name: "port_dvsi0_off2", desc: "Connect port off2 from port group dvsi0 to this pad." }
                      { value: "15", name: "port_dvsi0_off3", desc: "Connect port off3 from port group dvsi0 to this pad." }
                      { value: "16", name: "port_dvsi0_on0", desc: "Connect port on0 from port group dvsi0 to this pad." }
                      { value: "17", name: "port_dvsi0_on1", desc: "Connect port on1 from port group dvsi0 to this pad." }
                      { value: "18", name: "port_dvsi0_on2", desc: "Connect port on2 from port group dvsi0 to this pad." }
                      { value: "19", name: "port_dvsi0_on3", desc: "Connect port on3 from port group dvsi0 to this pad." }
                      { value: "20", name: "port_dvsi0_sxy", desc: "Connect port sxy from port group dvsi0 to this pad." }
                      { value: "21", name: "port_dvsi0_xclk", desc: "Connect port xclk from port group dvsi0 to this pad." }
                      { value: "22", name: "port_dvsi0_xnrst", desc: "Connect port xnrst from port group dvsi0 to this pad." }
                      { value: "23", name: "port_dvsi0_xydata0", desc: "Connect port xydata0 from port group dvsi0 to this pad." }
                      { value: "24", name: "port_dvsi0_xydata1", desc: "Connect port xydata1 from port group dvsi0 to this pad." }
                      { value: "25", name: "port_dvsi0_xydata2", desc: "Connect port xydata2 from port group dvsi0 to this pad." }
                      { value: "26", name: "port_dvsi0_xydata3", desc: "Connect port xydata3 from port group dvsi0 to this pad." }
                      { value: "27", name: "port_dvsi0_xydata4", desc: "Connect port xydata4 from port group dvsi0 to this pad." }
                      { value: "28", name: "port_dvsi0_xydata5", desc: "Connect port xydata5 from port group dvsi0 to this pad." }
                      { value: "29", name: "port_dvsi0_xydata6", desc: "Connect port xydata6 from port group dvsi0 to this pad." }
                      { value: "30", name: "port_dvsi0_xydata7", desc: "Connect port xydata7 from port group dvsi0 to this pad." }
                      { value: "31", name: "port_dvsi0_yclk", desc: "Connect port yclk from port group dvsi0 to this pad." }
                      { value: "32", name: "port_dvsi0_ynrst", desc: "Connect port ynrst from port group dvsi0 to this pad." }
                      { value: "33", name: "port_gpio_a_gpio25", desc: "Connect port gpio25 from port group gpio_a to this pad." }
                      { value: "34", name: "port_i2c0_i2c_scl", desc: "Connect port i2c_scl from port group i2c0 to this pad." }
                      { value: "35", name: "port_i2c0_i2c_sda", desc: "Connect port i2c_sda from port group i2c0 to this pad." }
                      { value: "36", name: "port_i2c1_i2c_scl", desc: "Connect port i2c_scl from port group i2c1 to this pad." }
                      { value: "37", name: "port_i2c1_i2c_sda", desc: "Connect port i2c_sda from port group i2c1 to this pad." }
                      { value: "38", name: "port_i2c2_i2c_scl", desc: "Connect port i2c_scl from port group i2c2 to this pad." }
                      { value: "39", name: "port_i2c2_i2c_sda", desc: "Connect port i2c_sda from port group i2c2 to this pad." }
                      { value: "40", name: "port_i2c3_i2c_scl", desc: "Connect port i2c_scl from port group i2c3 to this pad." }
                      { value: "41", name: "port_i2c3_i2c_sda", desc: "Connect port i2c_sda from port group i2c3 to this pad." }
                      { value: "42", name: "port_uart0_rx", desc: "Connect port rx from port group uart0 to this pad." }
                      { value: "43", name: "port_uart0_tx", desc: "Connect port tx from port group uart0 to this pad." }
                      { value: "44", name: "port_uart1_rx", desc: "Connect port rx from port group uart1 to this pad." }
                      { value: "45", name: "port_uart1_tx", desc: "Connect port tx from port group uart1 to this pad." }
                  ]
              }
          ]
      }

      {
          name: PAD_GPIOB0_CFG
          desc: '''
            Pad signal configuration.
          '''
          swaccess: "rw"
          fields: [
            {
                bits: "0"
                name: chip2pad
                desc: '''
                     The signal that connects to the pads TX driver
                '''
                swaccess: "rw"
                hwaccess: "hro"
                resval: "0"
            },
            {
                bits: "2:1"
                name: drv
                desc: '''
                     Driving strength selector
                '''
                swaccess: "rw"
                hwaccess: "hro"
                resval: "3"
            },
            {
                bits: "3"
                name: pde
                desc: '''
                     Pull down resistor enable
                '''
                swaccess: "rw"
                hwaccess: "hro"
                resval: "0"
            },
            {
                bits: "4"
                name: pue
                desc: '''
                     Pull up resistor enable
                '''
                swaccess: "rw"
                hwaccess: "hro"
                resval: "0"
            },
            {
                bits: "5"
                name: rxe
                desc: '''
                     Active high RX driver enable 
                '''
                swaccess: "rw"
                hwaccess: "hro"
                resval: "1"
            },
            {
                bits: "6"
                name: slw
                desc: '''
                     
                '''
                swaccess: "rw"
                hwaccess: "hro"
                resval: "0"
            },
            {
                bits: "7"
                name: smt
                desc: '''
                     Schmit trigger enable
                '''
                swaccess: "rw"
                hwaccess: "hro"
                resval: "0"
            },
            {
                bits: "8"
                name: trie
                desc: '''
                      Active high tri-state enable (active low TX driver enable)
                '''
                swaccess: "rw"
                hwaccess: "hro"
                resval: "1"
            },
          ]
      }

       {
          name: PAD_GPIOB0_MUX_SEL
          desc: '''
              Pad signal port multiplex selection for pad pad_gpiob0. The programmed value defines which port
              is connected to the pad.
          '''
          swaccess: "rw"
          hwaccess: "hro"
          resval: 0
          fields: [
              {
                  name: sel
                  desc: "Port selection index for pad pad_gpiob0."
                  bits: "5:0"
                  enum: [
                      { value: "0", name: "register", desc: "Connects the Pad to the internal configuration register."}
                      { value: "1", name: "port_gpio_b_gpio0", desc: "Connect port gpio0 from port group gpio_b to this pad." }
                      { value: "2", name: "port_qspi0_spi_csn0", desc: "Connect port spi_csn0 from port group qspi0 to this pad." }
                      { value: "3", name: "port_qspi0_spi_csn1", desc: "Connect port spi_csn1 from port group qspi0 to this pad." }
                      { value: "4", name: "port_qspi0_spi_csn2", desc: "Connect port spi_csn2 from port group qspi0 to this pad." }
                      { value: "5", name: "port_qspi0_spi_csn3", desc: "Connect port spi_csn3 from port group qspi0 to this pad." }
                      { value: "6", name: "port_qspi0_spi_sck", desc: "Connect port spi_sck from port group qspi0 to this pad." }
                      { value: "7", name: "port_qspi0_spi_sdio0", desc: "Connect port spi_sdio0 from port group qspi0 to this pad." }
                      { value: "8", name: "port_qspi0_spi_sdio1", desc: "Connect port spi_sdio1 from port group qspi0 to this pad." }
                      { value: "9", name: "port_qspi0_spi_sdio2", desc: "Connect port spi_sdio2 from port group qspi0 to this pad." }
                      { value: "10", name: "port_qspi0_spi_sdio3", desc: "Connect port spi_sdio3 from port group qspi0 to this pad." }
                      { value: "11", name: "port_qspi1_spi_csn0", desc: "Connect port spi_csn0 from port group qspi1 to this pad." }
                      { value: "12", name: "port_qspi1_spi_csn1", desc: "Connect port spi_csn1 from port group qspi1 to this pad." }
                      { value: "13", name: "port_qspi1_spi_csn2", desc: "Connect port spi_csn2 from port group qspi1 to this pad." }
                      { value: "14", name: "port_qspi1_spi_csn3", desc: "Connect port spi_csn3 from port group qspi1 to this pad." }
                      { value: "15", name: "port_qspi1_spi_sck", desc: "Connect port spi_sck from port group qspi1 to this pad." }
                      { value: "16", name: "port_qspi1_spi_sdio0", desc: "Connect port spi_sdio0 from port group qspi1 to this pad." }
                      { value: "17", name: "port_qspi1_spi_sdio1", desc: "Connect port spi_sdio1 from port group qspi1 to this pad." }
                      { value: "18", name: "port_qspi1_spi_sdio2", desc: "Connect port spi_sdio2 from port group qspi1 to this pad." }
                      { value: "19", name: "port_qspi1_spi_sdio3", desc: "Connect port spi_sdio3 from port group qspi1 to this pad." }
                      { value: "20", name: "port_qspi2_spi_csn0", desc: "Connect port spi_csn0 from port group qspi2 to this pad." }
                      { value: "21", name: "port_qspi2_spi_csn1", desc: "Connect port spi_csn1 from port group qspi2 to this pad." }
                      { value: "22", name: "port_qspi2_spi_csn2", desc: "Connect port spi_csn2 from port group qspi2 to this pad." }
                      { value: "23", name: "port_qspi2_spi_csn3", desc: "Connect port spi_csn3 from port group qspi2 to this pad." }
                      { value: "24", name: "port_qspi2_spi_sck", desc: "Connect port spi_sck from port group qspi2 to this pad." }
                      { value: "25", name: "port_qspi2_spi_sdio0", desc: "Connect port spi_sdio0 from port group qspi2 to this pad." }
                      { value: "26", name: "port_qspi2_spi_sdio1", desc: "Connect port spi_sdio1 from port group qspi2 to this pad." }
                      { value: "27", name: "port_qspi2_spi_sdio2", desc: "Connect port spi_sdio2 from port group qspi2 to this pad." }
                      { value: "28", name: "port_qspi2_spi_sdio3", desc: "Connect port spi_sdio3 from port group qspi2 to this pad." }
                      { value: "29", name: "port_qspi3_spi_csn0", desc: "Connect port spi_csn0 from port group qspi3 to this pad." }
                      { value: "30", name: "port_qspi3_spi_csn1", desc: "Connect port spi_csn1 from port group qspi3 to this pad." }
                      { value: "31", name: "port_qspi3_spi_csn2", desc: "Connect port spi_csn2 from port group qspi3 to this pad." }
                      { value: "32", name: "port_qspi3_spi_csn3", desc: "Connect port spi_csn3 from port group qspi3 to this pad." }
                      { value: "33", name: "port_qspi3_spi_sck", desc: "Connect port spi_sck from port group qspi3 to this pad." }
                      { value: "34", name: "port_qspi3_spi_sdio0", desc: "Connect port spi_sdio0 from port group qspi3 to this pad." }
                      { value: "35", name: "port_qspi3_spi_sdio1", desc: "Connect port spi_sdio1 from port group qspi3 to this pad." }
                      { value: "36", name: "port_qspi3_spi_sdio2", desc: "Connect port spi_sdio2 from port group qspi3 to this pad." }
                      { value: "37", name: "port_qspi3_spi_sdio3", desc: "Connect port spi_sdio3 from port group qspi3 to this pad." }
                      { value: "38", name: "port_timer0_out0", desc: "Connect port out0 from port group timer0 to this pad." }
                      { value: "39", name: "port_timer0_out1", desc: "Connect port out1 from port group timer0 to this pad." }
                      { value: "40", name: "port_timer0_out2", desc: "Connect port out2 from port group timer0 to this pad." }
                      { value: "41", name: "port_timer0_out3", desc: "Connect port out3 from port group timer0 to this pad." }
                      { value: "42", name: "port_timer1_out0", desc: "Connect port out0 from port group timer1 to this pad." }
                      { value: "43", name: "port_timer1_out1", desc: "Connect port out1 from port group timer1 to this pad." }
                      { value: "44", name: "port_timer1_out2", desc: "Connect port out2 from port group timer1 to this pad." }
                      { value: "45", name: "port_timer1_out3", desc: "Connect port out3 from port group timer1 to this pad." }
                      { value: "46", name: "port_timer2_out0", desc: "Connect port out0 from port group timer2 to this pad." }
                      { value: "47", name: "port_timer2_out1", desc: "Connect port out1 from port group timer2 to this pad." }
                      { value: "48", name: "port_timer2_out2", desc: "Connect port out2 from port group timer2 to this pad." }
                      { value: "49", name: "port_timer2_out3", desc: "Connect port out3 from port group timer2 to this pad." }
                      { value: "50", name: "port_timer3_out0", desc: "Connect port out0 from port group timer3 to this pad." }
                      { value: "51", name: "port_timer3_out1", desc: "Connect port out1 from port group timer3 to this pad." }
                      { value: "52", name: "port_timer3_out2", desc: "Connect port out2 from port group timer3 to this pad." }
                      { value: "53", name: "port_timer3_out3", desc: "Connect port out3 from port group timer3 to this pad." }
                  ]
              }
          ]
      }

      {
          name: PAD_GPIOB1_CFG
          desc: '''
            Pad signal configuration.
          '''
          swaccess: "rw"
          fields: [
            {
                bits: "0"
                name: chip2pad
                desc: '''
                     The signal that connects to the pads TX driver
                '''
                swaccess: "rw"
                hwaccess: "hro"
                resval: "0"
            },
            {
                bits: "2:1"
                name: drv
                desc: '''
                     Driving strength selector
                '''
                swaccess: "rw"
                hwaccess: "hro"
                resval: "3"
            },
            {
                bits: "3"
                name: pde
                desc: '''
                     Pull down resistor enable
                '''
                swaccess: "rw"
                hwaccess: "hro"
                resval: "0"
            },
            {
                bits: "4"
                name: pue
                desc: '''
                     Pull up resistor enable
                '''
                swaccess: "rw"
                hwaccess: "hro"
                resval: "0"
            },
            {
                bits: "5"
                name: rxe
                desc: '''
                     Active high RX driver enable 
                '''
                swaccess: "rw"
                hwaccess: "hro"
                resval: "1"
            },
            {
                bits: "6"
                name: slw
                desc: '''
                     
                '''
                swaccess: "rw"
                hwaccess: "hro"
                resval: "0"
            },
            {
                bits: "7"
                name: smt
                desc: '''
                     Schmit trigger enable
                '''
                swaccess: "rw"
                hwaccess: "hro"
                resval: "0"
            },
            {
                bits: "8"
                name: trie
                desc: '''
                      Active high tri-state enable (active low TX driver enable)
                '''
                swaccess: "rw"
                hwaccess: "hro"
                resval: "1"
            },
          ]
      }

       {
          name: PAD_GPIOB1_MUX_SEL
          desc: '''
              Pad signal port multiplex selection for pad pad_gpiob1. The programmed value defines which port
              is connected to the pad.
          '''
          swaccess: "rw"
          hwaccess: "hro"
          resval: 0
          fields: [
              {
                  name: sel
                  desc: "Port selection index for pad pad_gpiob1."
                  bits: "5:0"
                  enum: [
                      { value: "0", name: "register", desc: "Connects the Pad to the internal configuration register."}
                      { value: "1", name: "port_gpio_b_gpio1", desc: "Connect port gpio1 from port group gpio_b to this pad." }
                      { value: "2", name: "port_qspi0_spi_csn0", desc: "Connect port spi_csn0 from port group qspi0 to this pad." }
                      { value: "3", name: "port_qspi0_spi_csn1", desc: "Connect port spi_csn1 from port group qspi0 to this pad." }
                      { value: "4", name: "port_qspi0_spi_csn2", desc: "Connect port spi_csn2 from port group qspi0 to this pad." }
                      { value: "5", name: "port_qspi0_spi_csn3", desc: "Connect port spi_csn3 from port group qspi0 to this pad." }
                      { value: "6", name: "port_qspi0_spi_sck", desc: "Connect port spi_sck from port group qspi0 to this pad." }
                      { value: "7", name: "port_qspi0_spi_sdio0", desc: "Connect port spi_sdio0 from port group qspi0 to this pad." }
                      { value: "8", name: "port_qspi0_spi_sdio1", desc: "Connect port spi_sdio1 from port group qspi0 to this pad." }
                      { value: "9", name: "port_qspi0_spi_sdio2", desc: "Connect port spi_sdio2 from port group qspi0 to this pad." }
                      { value: "10", name: "port_qspi0_spi_sdio3", desc: "Connect port spi_sdio3 from port group qspi0 to this pad." }
                      { value: "11", name: "port_qspi1_spi_csn0", desc: "Connect port spi_csn0 from port group qspi1 to this pad." }
                      { value: "12", name: "port_qspi1_spi_csn1", desc: "Connect port spi_csn1 from port group qspi1 to this pad." }
                      { value: "13", name: "port_qspi1_spi_csn2", desc: "Connect port spi_csn2 from port group qspi1 to this pad." }
                      { value: "14", name: "port_qspi1_spi_csn3", desc: "Connect port spi_csn3 from port group qspi1 to this pad." }
                      { value: "15", name: "port_qspi1_spi_sck", desc: "Connect port spi_sck from port group qspi1 to this pad." }
                      { value: "16", name: "port_qspi1_spi_sdio0", desc: "Connect port spi_sdio0 from port group qspi1 to this pad." }
                      { value: "17", name: "port_qspi1_spi_sdio1", desc: "Connect port spi_sdio1 from port group qspi1 to this pad." }
                      { value: "18", name: "port_qspi1_spi_sdio2", desc: "Connect port spi_sdio2 from port group qspi1 to this pad." }
                      { value: "19", name: "port_qspi1_spi_sdio3", desc: "Connect port spi_sdio3 from port group qspi1 to this pad." }
                      { value: "20", name: "port_qspi2_spi_csn0", desc: "Connect port spi_csn0 from port group qspi2 to this pad." }
                      { value: "21", name: "port_qspi2_spi_csn1", desc: "Connect port spi_csn1 from port group qspi2 to this pad." }
                      { value: "22", name: "port_qspi2_spi_csn2", desc: "Connect port spi_csn2 from port group qspi2 to this pad." }
                      { value: "23", name: "port_qspi2_spi_csn3", desc: "Connect port spi_csn3 from port group qspi2 to this pad." }
                      { value: "24", name: "port_qspi2_spi_sck", desc: "Connect port spi_sck from port group qspi2 to this pad." }
                      { value: "25", name: "port_qspi2_spi_sdio0", desc: "Connect port spi_sdio0 from port group qspi2 to this pad." }
                      { value: "26", name: "port_qspi2_spi_sdio1", desc: "Connect port spi_sdio1 from port group qspi2 to this pad." }
                      { value: "27", name: "port_qspi2_spi_sdio2", desc: "Connect port spi_sdio2 from port group qspi2 to this pad." }
                      { value: "28", name: "port_qspi2_spi_sdio3", desc: "Connect port spi_sdio3 from port group qspi2 to this pad." }
                      { value: "29", name: "port_qspi3_spi_csn0", desc: "Connect port spi_csn0 from port group qspi3 to this pad." }
                      { value: "30", name: "port_qspi3_spi_csn1", desc: "Connect port spi_csn1 from port group qspi3 to this pad." }
                      { value: "31", name: "port_qspi3_spi_csn2", desc: "Connect port spi_csn2 from port group qspi3 to this pad." }
                      { value: "32", name: "port_qspi3_spi_csn3", desc: "Connect port spi_csn3 from port group qspi3 to this pad." }
                      { value: "33", name: "port_qspi3_spi_sck", desc: "Connect port spi_sck from port group qspi3 to this pad." }
                      { value: "34", name: "port_qspi3_spi_sdio0", desc: "Connect port spi_sdio0 from port group qspi3 to this pad." }
                      { value: "35", name: "port_qspi3_spi_sdio1", desc: "Connect port spi_sdio1 from port group qspi3 to this pad." }
                      { value: "36", name: "port_qspi3_spi_sdio2", desc: "Connect port spi_sdio2 from port group qspi3 to this pad." }
                      { value: "37", name: "port_qspi3_spi_sdio3", desc: "Connect port spi_sdio3 from port group qspi3 to this pad." }
                      { value: "38", name: "port_timer0_out0", desc: "Connect port out0 from port group timer0 to this pad." }
                      { value: "39", name: "port_timer0_out1", desc: "Connect port out1 from port group timer0 to this pad." }
                      { value: "40", name: "port_timer0_out2", desc: "Connect port out2 from port group timer0 to this pad." }
                      { value: "41", name: "port_timer0_out3", desc: "Connect port out3 from port group timer0 to this pad." }
                      { value: "42", name: "port_timer1_out0", desc: "Connect port out0 from port group timer1 to this pad." }
                      { value: "43", name: "port_timer1_out1", desc: "Connect port out1 from port group timer1 to this pad." }
                      { value: "44", name: "port_timer1_out2", desc: "Connect port out2 from port group timer1 to this pad." }
                      { value: "45", name: "port_timer1_out3", desc: "Connect port out3 from port group timer1 to this pad." }
                      { value: "46", name: "port_timer2_out0", desc: "Connect port out0 from port group timer2 to this pad." }
                      { value: "47", name: "port_timer2_out1", desc: "Connect port out1 from port group timer2 to this pad." }
                      { value: "48", name: "port_timer2_out2", desc: "Connect port out2 from port group timer2 to this pad." }
                      { value: "49", name: "port_timer2_out3", desc: "Connect port out3 from port group timer2 to this pad." }
                      { value: "50", name: "port_timer3_out0", desc: "Connect port out0 from port group timer3 to this pad." }
                      { value: "51", name: "port_timer3_out1", desc: "Connect port out1 from port group timer3 to this pad." }
                      { value: "52", name: "port_timer3_out2", desc: "Connect port out2 from port group timer3 to this pad." }
                      { value: "53", name: "port_timer3_out3", desc: "Connect port out3 from port group timer3 to this pad." }
                  ]
              }
          ]
      }

      {
          name: PAD_GPIOB2_CFG
          desc: '''
            Pad signal configuration.
          '''
          swaccess: "rw"
          fields: [
            {
                bits: "0"
                name: chip2pad
                desc: '''
                     The signal that connects to the pads TX driver
                '''
                swaccess: "rw"
                hwaccess: "hro"
                resval: "0"
            },
            {
                bits: "2:1"
                name: drv
                desc: '''
                     Driving strength selector
                '''
                swaccess: "rw"
                hwaccess: "hro"
                resval: "3"
            },
            {
                bits: "3"
                name: pde
                desc: '''
                     Pull down resistor enable
                '''
                swaccess: "rw"
                hwaccess: "hro"
                resval: "0"
            },
            {
                bits: "4"
                name: pue
                desc: '''
                     Pull up resistor enable
                '''
                swaccess: "rw"
                hwaccess: "hro"
                resval: "0"
            },
            {
                bits: "5"
                name: rxe
                desc: '''
                     Active high RX driver enable 
                '''
                swaccess: "rw"
                hwaccess: "hro"
                resval: "1"
            },
            {
                bits: "6"
                name: slw
                desc: '''
                     
                '''
                swaccess: "rw"
                hwaccess: "hro"
                resval: "0"
            },
            {
                bits: "7"
                name: smt
                desc: '''
                     Schmit trigger enable
                '''
                swaccess: "rw"
                hwaccess: "hro"
                resval: "0"
            },
            {
                bits: "8"
                name: trie
                desc: '''
                      Active high tri-state enable (active low TX driver enable)
                '''
                swaccess: "rw"
                hwaccess: "hro"
                resval: "1"
            },
          ]
      }

       {
          name: PAD_GPIOB2_MUX_SEL
          desc: '''
              Pad signal port multiplex selection for pad pad_gpiob2. The programmed value defines which port
              is connected to the pad.
          '''
          swaccess: "rw"
          hwaccess: "hro"
          resval: 0
          fields: [
              {
                  name: sel
                  desc: "Port selection index for pad pad_gpiob2."
                  bits: "5:0"
                  enum: [
                      { value: "0", name: "register", desc: "Connects the Pad to the internal configuration register."}
                      { value: "1", name: "port_gpio_b_gpio2", desc: "Connect port gpio2 from port group gpio_b to this pad." }
                      { value: "2", name: "port_qspi0_spi_csn0", desc: "Connect port spi_csn0 from port group qspi0 to this pad." }
                      { value: "3", name: "port_qspi0_spi_csn1", desc: "Connect port spi_csn1 from port group qspi0 to this pad." }
                      { value: "4", name: "port_qspi0_spi_csn2", desc: "Connect port spi_csn2 from port group qspi0 to this pad." }
                      { value: "5", name: "port_qspi0_spi_csn3", desc: "Connect port spi_csn3 from port group qspi0 to this pad." }
                      { value: "6", name: "port_qspi0_spi_sck", desc: "Connect port spi_sck from port group qspi0 to this pad." }
                      { value: "7", name: "port_qspi0_spi_sdio0", desc: "Connect port spi_sdio0 from port group qspi0 to this pad." }
                      { value: "8", name: "port_qspi0_spi_sdio1", desc: "Connect port spi_sdio1 from port group qspi0 to this pad." }
                      { value: "9", name: "port_qspi0_spi_sdio2", desc: "Connect port spi_sdio2 from port group qspi0 to this pad." }
                      { value: "10", name: "port_qspi0_spi_sdio3", desc: "Connect port spi_sdio3 from port group qspi0 to this pad." }
                      { value: "11", name: "port_qspi1_spi_csn0", desc: "Connect port spi_csn0 from port group qspi1 to this pad." }
                      { value: "12", name: "port_qspi1_spi_csn1", desc: "Connect port spi_csn1 from port group qspi1 to this pad." }
                      { value: "13", name: "port_qspi1_spi_csn2", desc: "Connect port spi_csn2 from port group qspi1 to this pad." }
                      { value: "14", name: "port_qspi1_spi_csn3", desc: "Connect port spi_csn3 from port group qspi1 to this pad." }
                      { value: "15", name: "port_qspi1_spi_sck", desc: "Connect port spi_sck from port group qspi1 to this pad." }
                      { value: "16", name: "port_qspi1_spi_sdio0", desc: "Connect port spi_sdio0 from port group qspi1 to this pad." }
                      { value: "17", name: "port_qspi1_spi_sdio1", desc: "Connect port spi_sdio1 from port group qspi1 to this pad." }
                      { value: "18", name: "port_qspi1_spi_sdio2", desc: "Connect port spi_sdio2 from port group qspi1 to this pad." }
                      { value: "19", name: "port_qspi1_spi_sdio3", desc: "Connect port spi_sdio3 from port group qspi1 to this pad." }
                      { value: "20", name: "port_qspi2_spi_csn0", desc: "Connect port spi_csn0 from port group qspi2 to this pad." }
                      { value: "21", name: "port_qspi2_spi_csn1", desc: "Connect port spi_csn1 from port group qspi2 to this pad." }
                      { value: "22", name: "port_qspi2_spi_csn2", desc: "Connect port spi_csn2 from port group qspi2 to this pad." }
                      { value: "23", name: "port_qspi2_spi_csn3", desc: "Connect port spi_csn3 from port group qspi2 to this pad." }
                      { value: "24", name: "port_qspi2_spi_sck", desc: "Connect port spi_sck from port group qspi2 to this pad." }
                      { value: "25", name: "port_qspi2_spi_sdio0", desc: "Connect port spi_sdio0 from port group qspi2 to this pad." }
                      { value: "26", name: "port_qspi2_spi_sdio1", desc: "Connect port spi_sdio1 from port group qspi2 to this pad." }
                      { value: "27", name: "port_qspi2_spi_sdio2", desc: "Connect port spi_sdio2 from port group qspi2 to this pad." }
                      { value: "28", name: "port_qspi2_spi_sdio3", desc: "Connect port spi_sdio3 from port group qspi2 to this pad." }
                      { value: "29", name: "port_qspi3_spi_csn0", desc: "Connect port spi_csn0 from port group qspi3 to this pad." }
                      { value: "30", name: "port_qspi3_spi_csn1", desc: "Connect port spi_csn1 from port group qspi3 to this pad." }
                      { value: "31", name: "port_qspi3_spi_csn2", desc: "Connect port spi_csn2 from port group qspi3 to this pad." }
                      { value: "32", name: "port_qspi3_spi_csn3", desc: "Connect port spi_csn3 from port group qspi3 to this pad." }
                      { value: "33", name: "port_qspi3_spi_sck", desc: "Connect port spi_sck from port group qspi3 to this pad." }
                      { value: "34", name: "port_qspi3_spi_sdio0", desc: "Connect port spi_sdio0 from port group qspi3 to this pad." }
                      { value: "35", name: "port_qspi3_spi_sdio1", desc: "Connect port spi_sdio1 from port group qspi3 to this pad." }
                      { value: "36", name: "port_qspi3_spi_sdio2", desc: "Connect port spi_sdio2 from port group qspi3 to this pad." }
                      { value: "37", name: "port_qspi3_spi_sdio3", desc: "Connect port spi_sdio3 from port group qspi3 to this pad." }
                      { value: "38", name: "port_timer0_out0", desc: "Connect port out0 from port group timer0 to this pad." }
                      { value: "39", name: "port_timer0_out1", desc: "Connect port out1 from port group timer0 to this pad." }
                      { value: "40", name: "port_timer0_out2", desc: "Connect port out2 from port group timer0 to this pad." }
                      { value: "41", name: "port_timer0_out3", desc: "Connect port out3 from port group timer0 to this pad." }
                      { value: "42", name: "port_timer1_out0", desc: "Connect port out0 from port group timer1 to this pad." }
                      { value: "43", name: "port_timer1_out1", desc: "Connect port out1 from port group timer1 to this pad." }
                      { value: "44", name: "port_timer1_out2", desc: "Connect port out2 from port group timer1 to this pad." }
                      { value: "45", name: "port_timer1_out3", desc: "Connect port out3 from port group timer1 to this pad." }
                      { value: "46", name: "port_timer2_out0", desc: "Connect port out0 from port group timer2 to this pad." }
                      { value: "47", name: "port_timer2_out1", desc: "Connect port out1 from port group timer2 to this pad." }
                      { value: "48", name: "port_timer2_out2", desc: "Connect port out2 from port group timer2 to this pad." }
                      { value: "49", name: "port_timer2_out3", desc: "Connect port out3 from port group timer2 to this pad." }
                      { value: "50", name: "port_timer3_out0", desc: "Connect port out0 from port group timer3 to this pad." }
                      { value: "51", name: "port_timer3_out1", desc: "Connect port out1 from port group timer3 to this pad." }
                      { value: "52", name: "port_timer3_out2", desc: "Connect port out2 from port group timer3 to this pad." }
                      { value: "53", name: "port_timer3_out3", desc: "Connect port out3 from port group timer3 to this pad." }
                  ]
              }
          ]
      }

      {
          name: PAD_GPIOB3_CFG
          desc: '''
            Pad signal configuration.
          '''
          swaccess: "rw"
          fields: [
            {
                bits: "0"
                name: chip2pad
                desc: '''
                     The signal that connects to the pads TX driver
                '''
                swaccess: "rw"
                hwaccess: "hro"
                resval: "0"
            },
            {
                bits: "2:1"
                name: drv
                desc: '''
                     Driving strength selector
                '''
                swaccess: "rw"
                hwaccess: "hro"
                resval: "3"
            },
            {
                bits: "3"
                name: pde
                desc: '''
                     Pull down resistor enable
                '''
                swaccess: "rw"
                hwaccess: "hro"
                resval: "0"
            },
            {
                bits: "4"
                name: pue
                desc: '''
                     Pull up resistor enable
                '''
                swaccess: "rw"
                hwaccess: "hro"
                resval: "0"
            },
            {
                bits: "5"
                name: rxe
                desc: '''
                     Active high RX driver enable 
                '''
                swaccess: "rw"
                hwaccess: "hro"
                resval: "1"
            },
            {
                bits: "6"
                name: slw
                desc: '''
                     
                '''
                swaccess: "rw"
                hwaccess: "hro"
                resval: "0"
            },
            {
                bits: "7"
                name: smt
                desc: '''
                     Schmit trigger enable
                '''
                swaccess: "rw"
                hwaccess: "hro"
                resval: "0"
            },
            {
                bits: "8"
                name: trie
                desc: '''
                      Active high tri-state enable (active low TX driver enable)
                '''
                swaccess: "rw"
                hwaccess: "hro"
                resval: "1"
            },
          ]
      }

       {
          name: PAD_GPIOB3_MUX_SEL
          desc: '''
              Pad signal port multiplex selection for pad pad_gpiob3. The programmed value defines which port
              is connected to the pad.
          '''
          swaccess: "rw"
          hwaccess: "hro"
          resval: 0
          fields: [
              {
                  name: sel
                  desc: "Port selection index for pad pad_gpiob3."
                  bits: "5:0"
                  enum: [
                      { value: "0", name: "register", desc: "Connects the Pad to the internal configuration register."}
                      { value: "1", name: "port_gpio_b_gpio3", desc: "Connect port gpio3 from port group gpio_b to this pad." }
                      { value: "2", name: "port_qspi0_spi_csn0", desc: "Connect port spi_csn0 from port group qspi0 to this pad." }
                      { value: "3", name: "port_qspi0_spi_csn1", desc: "Connect port spi_csn1 from port group qspi0 to this pad." }
                      { value: "4", name: "port_qspi0_spi_csn2", desc: "Connect port spi_csn2 from port group qspi0 to this pad." }
                      { value: "5", name: "port_qspi0_spi_csn3", desc: "Connect port spi_csn3 from port group qspi0 to this pad." }
                      { value: "6", name: "port_qspi0_spi_sck", desc: "Connect port spi_sck from port group qspi0 to this pad." }
                      { value: "7", name: "port_qspi0_spi_sdio0", desc: "Connect port spi_sdio0 from port group qspi0 to this pad." }
                      { value: "8", name: "port_qspi0_spi_sdio1", desc: "Connect port spi_sdio1 from port group qspi0 to this pad." }
                      { value: "9", name: "port_qspi0_spi_sdio2", desc: "Connect port spi_sdio2 from port group qspi0 to this pad." }
                      { value: "10", name: "port_qspi0_spi_sdio3", desc: "Connect port spi_sdio3 from port group qspi0 to this pad." }
                      { value: "11", name: "port_qspi1_spi_csn0", desc: "Connect port spi_csn0 from port group qspi1 to this pad." }
                      { value: "12", name: "port_qspi1_spi_csn1", desc: "Connect port spi_csn1 from port group qspi1 to this pad." }
                      { value: "13", name: "port_qspi1_spi_csn2", desc: "Connect port spi_csn2 from port group qspi1 to this pad." }
                      { value: "14", name: "port_qspi1_spi_csn3", desc: "Connect port spi_csn3 from port group qspi1 to this pad." }
                      { value: "15", name: "port_qspi1_spi_sck", desc: "Connect port spi_sck from port group qspi1 to this pad." }
                      { value: "16", name: "port_qspi1_spi_sdio0", desc: "Connect port spi_sdio0 from port group qspi1 to this pad." }
                      { value: "17", name: "port_qspi1_spi_sdio1", desc: "Connect port spi_sdio1 from port group qspi1 to this pad." }
                      { value: "18", name: "port_qspi1_spi_sdio2", desc: "Connect port spi_sdio2 from port group qspi1 to this pad." }
                      { value: "19", name: "port_qspi1_spi_sdio3", desc: "Connect port spi_sdio3 from port group qspi1 to this pad." }
                      { value: "20", name: "port_qspi2_spi_csn0", desc: "Connect port spi_csn0 from port group qspi2 to this pad." }
                      { value: "21", name: "port_qspi2_spi_csn1", desc: "Connect port spi_csn1 from port group qspi2 to this pad." }
                      { value: "22", name: "port_qspi2_spi_csn2", desc: "Connect port spi_csn2 from port group qspi2 to this pad." }
                      { value: "23", name: "port_qspi2_spi_csn3", desc: "Connect port spi_csn3 from port group qspi2 to this pad." }
                      { value: "24", name: "port_qspi2_spi_sck", desc: "Connect port spi_sck from port group qspi2 to this pad." }
                      { value: "25", name: "port_qspi2_spi_sdio0", desc: "Connect port spi_sdio0 from port group qspi2 to this pad." }
                      { value: "26", name: "port_qspi2_spi_sdio1", desc: "Connect port spi_sdio1 from port group qspi2 to this pad." }
                      { value: "27", name: "port_qspi2_spi_sdio2", desc: "Connect port spi_sdio2 from port group qspi2 to this pad." }
                      { value: "28", name: "port_qspi2_spi_sdio3", desc: "Connect port spi_sdio3 from port group qspi2 to this pad." }
                      { value: "29", name: "port_qspi3_spi_csn0", desc: "Connect port spi_csn0 from port group qspi3 to this pad." }
                      { value: "30", name: "port_qspi3_spi_csn1", desc: "Connect port spi_csn1 from port group qspi3 to this pad." }
                      { value: "31", name: "port_qspi3_spi_csn2", desc: "Connect port spi_csn2 from port group qspi3 to this pad." }
                      { value: "32", name: "port_qspi3_spi_csn3", desc: "Connect port spi_csn3 from port group qspi3 to this pad." }
                      { value: "33", name: "port_qspi3_spi_sck", desc: "Connect port spi_sck from port group qspi3 to this pad." }
                      { value: "34", name: "port_qspi3_spi_sdio0", desc: "Connect port spi_sdio0 from port group qspi3 to this pad." }
                      { value: "35", name: "port_qspi3_spi_sdio1", desc: "Connect port spi_sdio1 from port group qspi3 to this pad." }
                      { value: "36", name: "port_qspi3_spi_sdio2", desc: "Connect port spi_sdio2 from port group qspi3 to this pad." }
                      { value: "37", name: "port_qspi3_spi_sdio3", desc: "Connect port spi_sdio3 from port group qspi3 to this pad." }
                      { value: "38", name: "port_timer0_out0", desc: "Connect port out0 from port group timer0 to this pad." }
                      { value: "39", name: "port_timer0_out1", desc: "Connect port out1 from port group timer0 to this pad." }
                      { value: "40", name: "port_timer0_out2", desc: "Connect port out2 from port group timer0 to this pad." }
                      { value: "41", name: "port_timer0_out3", desc: "Connect port out3 from port group timer0 to this pad." }
                      { value: "42", name: "port_timer1_out0", desc: "Connect port out0 from port group timer1 to this pad." }
                      { value: "43", name: "port_timer1_out1", desc: "Connect port out1 from port group timer1 to this pad." }
                      { value: "44", name: "port_timer1_out2", desc: "Connect port out2 from port group timer1 to this pad." }
                      { value: "45", name: "port_timer1_out3", desc: "Connect port out3 from port group timer1 to this pad." }
                      { value: "46", name: "port_timer2_out0", desc: "Connect port out0 from port group timer2 to this pad." }
                      { value: "47", name: "port_timer2_out1", desc: "Connect port out1 from port group timer2 to this pad." }
                      { value: "48", name: "port_timer2_out2", desc: "Connect port out2 from port group timer2 to this pad." }
                      { value: "49", name: "port_timer2_out3", desc: "Connect port out3 from port group timer2 to this pad." }
                      { value: "50", name: "port_timer3_out0", desc: "Connect port out0 from port group timer3 to this pad." }
                      { value: "51", name: "port_timer3_out1", desc: "Connect port out1 from port group timer3 to this pad." }
                      { value: "52", name: "port_timer3_out2", desc: "Connect port out2 from port group timer3 to this pad." }
                      { value: "53", name: "port_timer3_out3", desc: "Connect port out3 from port group timer3 to this pad." }
                  ]
              }
          ]
      }

      {
          name: PAD_GPIOB4_CFG
          desc: '''
            Pad signal configuration.
          '''
          swaccess: "rw"
          fields: [
            {
                bits: "0"
                name: chip2pad
                desc: '''
                     The signal that connects to the pads TX driver
                '''
                swaccess: "rw"
                hwaccess: "hro"
                resval: "0"
            },
            {
                bits: "2:1"
                name: drv
                desc: '''
                     Driving strength selector
                '''
                swaccess: "rw"
                hwaccess: "hro"
                resval: "3"
            },
            {
                bits: "3"
                name: pde
                desc: '''
                     Pull down resistor enable
                '''
                swaccess: "rw"
                hwaccess: "hro"
                resval: "0"
            },
            {
                bits: "4"
                name: pue
                desc: '''
                     Pull up resistor enable
                '''
                swaccess: "rw"
                hwaccess: "hro"
                resval: "0"
            },
            {
                bits: "5"
                name: rxe
                desc: '''
                     Active high RX driver enable 
                '''
                swaccess: "rw"
                hwaccess: "hro"
                resval: "1"
            },
            {
                bits: "6"
                name: slw
                desc: '''
                     
                '''
                swaccess: "rw"
                hwaccess: "hro"
                resval: "0"
            },
            {
                bits: "7"
                name: smt
                desc: '''
                     Schmit trigger enable
                '''
                swaccess: "rw"
                hwaccess: "hro"
                resval: "0"
            },
            {
                bits: "8"
                name: trie
                desc: '''
                      Active high tri-state enable (active low TX driver enable)
                '''
                swaccess: "rw"
                hwaccess: "hro"
                resval: "1"
            },
          ]
      }

       {
          name: PAD_GPIOB4_MUX_SEL
          desc: '''
              Pad signal port multiplex selection for pad pad_gpiob4. The programmed value defines which port
              is connected to the pad.
          '''
          swaccess: "rw"
          hwaccess: "hro"
          resval: 0
          fields: [
              {
                  name: sel
                  desc: "Port selection index for pad pad_gpiob4."
                  bits: "5:0"
                  enum: [
                      { value: "0", name: "register", desc: "Connects the Pad to the internal configuration register."}
                      { value: "1", name: "port_gpio_b_gpio4", desc: "Connect port gpio4 from port group gpio_b to this pad." }
                      { value: "2", name: "port_qspi0_spi_csn0", desc: "Connect port spi_csn0 from port group qspi0 to this pad." }
                      { value: "3", name: "port_qspi0_spi_csn1", desc: "Connect port spi_csn1 from port group qspi0 to this pad." }
                      { value: "4", name: "port_qspi0_spi_csn2", desc: "Connect port spi_csn2 from port group qspi0 to this pad." }
                      { value: "5", name: "port_qspi0_spi_csn3", desc: "Connect port spi_csn3 from port group qspi0 to this pad." }
                      { value: "6", name: "port_qspi0_spi_sck", desc: "Connect port spi_sck from port group qspi0 to this pad." }
                      { value: "7", name: "port_qspi0_spi_sdio0", desc: "Connect port spi_sdio0 from port group qspi0 to this pad." }
                      { value: "8", name: "port_qspi0_spi_sdio1", desc: "Connect port spi_sdio1 from port group qspi0 to this pad." }
                      { value: "9", name: "port_qspi0_spi_sdio2", desc: "Connect port spi_sdio2 from port group qspi0 to this pad." }
                      { value: "10", name: "port_qspi0_spi_sdio3", desc: "Connect port spi_sdio3 from port group qspi0 to this pad." }
                      { value: "11", name: "port_qspi1_spi_csn0", desc: "Connect port spi_csn0 from port group qspi1 to this pad." }
                      { value: "12", name: "port_qspi1_spi_csn1", desc: "Connect port spi_csn1 from port group qspi1 to this pad." }
                      { value: "13", name: "port_qspi1_spi_csn2", desc: "Connect port spi_csn2 from port group qspi1 to this pad." }
                      { value: "14", name: "port_qspi1_spi_csn3", desc: "Connect port spi_csn3 from port group qspi1 to this pad." }
                      { value: "15", name: "port_qspi1_spi_sck", desc: "Connect port spi_sck from port group qspi1 to this pad." }
                      { value: "16", name: "port_qspi1_spi_sdio0", desc: "Connect port spi_sdio0 from port group qspi1 to this pad." }
                      { value: "17", name: "port_qspi1_spi_sdio1", desc: "Connect port spi_sdio1 from port group qspi1 to this pad." }
                      { value: "18", name: "port_qspi1_spi_sdio2", desc: "Connect port spi_sdio2 from port group qspi1 to this pad." }
                      { value: "19", name: "port_qspi1_spi_sdio3", desc: "Connect port spi_sdio3 from port group qspi1 to this pad." }
                      { value: "20", name: "port_qspi2_spi_csn0", desc: "Connect port spi_csn0 from port group qspi2 to this pad." }
                      { value: "21", name: "port_qspi2_spi_csn1", desc: "Connect port spi_csn1 from port group qspi2 to this pad." }
                      { value: "22", name: "port_qspi2_spi_csn2", desc: "Connect port spi_csn2 from port group qspi2 to this pad." }
                      { value: "23", name: "port_qspi2_spi_csn3", desc: "Connect port spi_csn3 from port group qspi2 to this pad." }
                      { value: "24", name: "port_qspi2_spi_sck", desc: "Connect port spi_sck from port group qspi2 to this pad." }
                      { value: "25", name: "port_qspi2_spi_sdio0", desc: "Connect port spi_sdio0 from port group qspi2 to this pad." }
                      { value: "26", name: "port_qspi2_spi_sdio1", desc: "Connect port spi_sdio1 from port group qspi2 to this pad." }
                      { value: "27", name: "port_qspi2_spi_sdio2", desc: "Connect port spi_sdio2 from port group qspi2 to this pad." }
                      { value: "28", name: "port_qspi2_spi_sdio3", desc: "Connect port spi_sdio3 from port group qspi2 to this pad." }
                      { value: "29", name: "port_qspi3_spi_csn0", desc: "Connect port spi_csn0 from port group qspi3 to this pad." }
                      { value: "30", name: "port_qspi3_spi_csn1", desc: "Connect port spi_csn1 from port group qspi3 to this pad." }
                      { value: "31", name: "port_qspi3_spi_csn2", desc: "Connect port spi_csn2 from port group qspi3 to this pad." }
                      { value: "32", name: "port_qspi3_spi_csn3", desc: "Connect port spi_csn3 from port group qspi3 to this pad." }
                      { value: "33", name: "port_qspi3_spi_sck", desc: "Connect port spi_sck from port group qspi3 to this pad." }
                      { value: "34", name: "port_qspi3_spi_sdio0", desc: "Connect port spi_sdio0 from port group qspi3 to this pad." }
                      { value: "35", name: "port_qspi3_spi_sdio1", desc: "Connect port spi_sdio1 from port group qspi3 to this pad." }
                      { value: "36", name: "port_qspi3_spi_sdio2", desc: "Connect port spi_sdio2 from port group qspi3 to this pad." }
                      { value: "37", name: "port_qspi3_spi_sdio3", desc: "Connect port spi_sdio3 from port group qspi3 to this pad." }
                      { value: "38", name: "port_timer0_out0", desc: "Connect port out0 from port group timer0 to this pad." }
                      { value: "39", name: "port_timer0_out1", desc: "Connect port out1 from port group timer0 to this pad." }
                      { value: "40", name: "port_timer0_out2", desc: "Connect port out2 from port group timer0 to this pad." }
                      { value: "41", name: "port_timer0_out3", desc: "Connect port out3 from port group timer0 to this pad." }
                      { value: "42", name: "port_timer1_out0", desc: "Connect port out0 from port group timer1 to this pad." }
                      { value: "43", name: "port_timer1_out1", desc: "Connect port out1 from port group timer1 to this pad." }
                      { value: "44", name: "port_timer1_out2", desc: "Connect port out2 from port group timer1 to this pad." }
                      { value: "45", name: "port_timer1_out3", desc: "Connect port out3 from port group timer1 to this pad." }
                      { value: "46", name: "port_timer2_out0", desc: "Connect port out0 from port group timer2 to this pad." }
                      { value: "47", name: "port_timer2_out1", desc: "Connect port out1 from port group timer2 to this pad." }
                      { value: "48", name: "port_timer2_out2", desc: "Connect port out2 from port group timer2 to this pad." }
                      { value: "49", name: "port_timer2_out3", desc: "Connect port out3 from port group timer2 to this pad." }
                      { value: "50", name: "port_timer3_out0", desc: "Connect port out0 from port group timer3 to this pad." }
                      { value: "51", name: "port_timer3_out1", desc: "Connect port out1 from port group timer3 to this pad." }
                      { value: "52", name: "port_timer3_out2", desc: "Connect port out2 from port group timer3 to this pad." }
                      { value: "53", name: "port_timer3_out3", desc: "Connect port out3 from port group timer3 to this pad." }
                  ]
              }
          ]
      }

      {
          name: PAD_GPIOB5_CFG
          desc: '''
            Pad signal configuration.
          '''
          swaccess: "rw"
          fields: [
            {
                bits: "0"
                name: chip2pad
                desc: '''
                     The signal that connects to the pads TX driver
                '''
                swaccess: "rw"
                hwaccess: "hro"
                resval: "0"
            },
            {
                bits: "2:1"
                name: drv
                desc: '''
                     Driving strength selector
                '''
                swaccess: "rw"
                hwaccess: "hro"
                resval: "3"
            },
            {
                bits: "3"
                name: pde
                desc: '''
                     Pull down resistor enable
                '''
                swaccess: "rw"
                hwaccess: "hro"
                resval: "0"
            },
            {
                bits: "4"
                name: pue
                desc: '''
                     Pull up resistor enable
                '''
                swaccess: "rw"
                hwaccess: "hro"
                resval: "0"
            },
            {
                bits: "5"
                name: rxe
                desc: '''
                     Active high RX driver enable 
                '''
                swaccess: "rw"
                hwaccess: "hro"
                resval: "1"
            },
            {
                bits: "6"
                name: slw
                desc: '''
                     
                '''
                swaccess: "rw"
                hwaccess: "hro"
                resval: "0"
            },
            {
                bits: "7"
                name: smt
                desc: '''
                     Schmit trigger enable
                '''
                swaccess: "rw"
                hwaccess: "hro"
                resval: "0"
            },
            {
                bits: "8"
                name: trie
                desc: '''
                      Active high tri-state enable (active low TX driver enable)
                '''
                swaccess: "rw"
                hwaccess: "hro"
                resval: "1"
            },
          ]
      }

       {
          name: PAD_GPIOB5_MUX_SEL
          desc: '''
              Pad signal port multiplex selection for pad pad_gpiob5. The programmed value defines which port
              is connected to the pad.
          '''
          swaccess: "rw"
          hwaccess: "hro"
          resval: 0
          fields: [
              {
                  name: sel
                  desc: "Port selection index for pad pad_gpiob5."
                  bits: "5:0"
                  enum: [
                      { value: "0", name: "register", desc: "Connects the Pad to the internal configuration register."}
                      { value: "1", name: "port_gpio_b_gpio5", desc: "Connect port gpio5 from port group gpio_b to this pad." }
                      { value: "2", name: "port_qspi0_spi_csn0", desc: "Connect port spi_csn0 from port group qspi0 to this pad." }
                      { value: "3", name: "port_qspi0_spi_csn1", desc: "Connect port spi_csn1 from port group qspi0 to this pad." }
                      { value: "4", name: "port_qspi0_spi_csn2", desc: "Connect port spi_csn2 from port group qspi0 to this pad." }
                      { value: "5", name: "port_qspi0_spi_csn3", desc: "Connect port spi_csn3 from port group qspi0 to this pad." }
                      { value: "6", name: "port_qspi0_spi_sck", desc: "Connect port spi_sck from port group qspi0 to this pad." }
                      { value: "7", name: "port_qspi0_spi_sdio0", desc: "Connect port spi_sdio0 from port group qspi0 to this pad." }
                      { value: "8", name: "port_qspi0_spi_sdio1", desc: "Connect port spi_sdio1 from port group qspi0 to this pad." }
                      { value: "9", name: "port_qspi0_spi_sdio2", desc: "Connect port spi_sdio2 from port group qspi0 to this pad." }
                      { value: "10", name: "port_qspi0_spi_sdio3", desc: "Connect port spi_sdio3 from port group qspi0 to this pad." }
                      { value: "11", name: "port_qspi1_spi_csn0", desc: "Connect port spi_csn0 from port group qspi1 to this pad." }
                      { value: "12", name: "port_qspi1_spi_csn1", desc: "Connect port spi_csn1 from port group qspi1 to this pad." }
                      { value: "13", name: "port_qspi1_spi_csn2", desc: "Connect port spi_csn2 from port group qspi1 to this pad." }
                      { value: "14", name: "port_qspi1_spi_csn3", desc: "Connect port spi_csn3 from port group qspi1 to this pad." }
                      { value: "15", name: "port_qspi1_spi_sck", desc: "Connect port spi_sck from port group qspi1 to this pad." }
                      { value: "16", name: "port_qspi1_spi_sdio0", desc: "Connect port spi_sdio0 from port group qspi1 to this pad." }
                      { value: "17", name: "port_qspi1_spi_sdio1", desc: "Connect port spi_sdio1 from port group qspi1 to this pad." }
                      { value: "18", name: "port_qspi1_spi_sdio2", desc: "Connect port spi_sdio2 from port group qspi1 to this pad." }
                      { value: "19", name: "port_qspi1_spi_sdio3", desc: "Connect port spi_sdio3 from port group qspi1 to this pad." }
                      { value: "20", name: "port_qspi2_spi_csn0", desc: "Connect port spi_csn0 from port group qspi2 to this pad." }
                      { value: "21", name: "port_qspi2_spi_csn1", desc: "Connect port spi_csn1 from port group qspi2 to this pad." }
                      { value: "22", name: "port_qspi2_spi_csn2", desc: "Connect port spi_csn2 from port group qspi2 to this pad." }
                      { value: "23", name: "port_qspi2_spi_csn3", desc: "Connect port spi_csn3 from port group qspi2 to this pad." }
                      { value: "24", name: "port_qspi2_spi_sck", desc: "Connect port spi_sck from port group qspi2 to this pad." }
                      { value: "25", name: "port_qspi2_spi_sdio0", desc: "Connect port spi_sdio0 from port group qspi2 to this pad." }
                      { value: "26", name: "port_qspi2_spi_sdio1", desc: "Connect port spi_sdio1 from port group qspi2 to this pad." }
                      { value: "27", name: "port_qspi2_spi_sdio2", desc: "Connect port spi_sdio2 from port group qspi2 to this pad." }
                      { value: "28", name: "port_qspi2_spi_sdio3", desc: "Connect port spi_sdio3 from port group qspi2 to this pad." }
                      { value: "29", name: "port_qspi3_spi_csn0", desc: "Connect port spi_csn0 from port group qspi3 to this pad." }
                      { value: "30", name: "port_qspi3_spi_csn1", desc: "Connect port spi_csn1 from port group qspi3 to this pad." }
                      { value: "31", name: "port_qspi3_spi_csn2", desc: "Connect port spi_csn2 from port group qspi3 to this pad." }
                      { value: "32", name: "port_qspi3_spi_csn3", desc: "Connect port spi_csn3 from port group qspi3 to this pad." }
                      { value: "33", name: "port_qspi3_spi_sck", desc: "Connect port spi_sck from port group qspi3 to this pad." }
                      { value: "34", name: "port_qspi3_spi_sdio0", desc: "Connect port spi_sdio0 from port group qspi3 to this pad." }
                      { value: "35", name: "port_qspi3_spi_sdio1", desc: "Connect port spi_sdio1 from port group qspi3 to this pad." }
                      { value: "36", name: "port_qspi3_spi_sdio2", desc: "Connect port spi_sdio2 from port group qspi3 to this pad." }
                      { value: "37", name: "port_qspi3_spi_sdio3", desc: "Connect port spi_sdio3 from port group qspi3 to this pad." }
                      { value: "38", name: "port_timer0_out0", desc: "Connect port out0 from port group timer0 to this pad." }
                      { value: "39", name: "port_timer0_out1", desc: "Connect port out1 from port group timer0 to this pad." }
                      { value: "40", name: "port_timer0_out2", desc: "Connect port out2 from port group timer0 to this pad." }
                      { value: "41", name: "port_timer0_out3", desc: "Connect port out3 from port group timer0 to this pad." }
                      { value: "42", name: "port_timer1_out0", desc: "Connect port out0 from port group timer1 to this pad." }
                      { value: "43", name: "port_timer1_out1", desc: "Connect port out1 from port group timer1 to this pad." }
                      { value: "44", name: "port_timer1_out2", desc: "Connect port out2 from port group timer1 to this pad." }
                      { value: "45", name: "port_timer1_out3", desc: "Connect port out3 from port group timer1 to this pad." }
                      { value: "46", name: "port_timer2_out0", desc: "Connect port out0 from port group timer2 to this pad." }
                      { value: "47", name: "port_timer2_out1", desc: "Connect port out1 from port group timer2 to this pad." }
                      { value: "48", name: "port_timer2_out2", desc: "Connect port out2 from port group timer2 to this pad." }
                      { value: "49", name: "port_timer2_out3", desc: "Connect port out3 from port group timer2 to this pad." }
                      { value: "50", name: "port_timer3_out0", desc: "Connect port out0 from port group timer3 to this pad." }
                      { value: "51", name: "port_timer3_out1", desc: "Connect port out1 from port group timer3 to this pad." }
                      { value: "52", name: "port_timer3_out2", desc: "Connect port out2 from port group timer3 to this pad." }
                      { value: "53", name: "port_timer3_out3", desc: "Connect port out3 from port group timer3 to this pad." }
                  ]
              }
          ]
      }

      {
          name: PAD_GPIOB6_CFG
          desc: '''
            Pad signal configuration.
          '''
          swaccess: "rw"
          fields: [
            {
                bits: "0"
                name: chip2pad
                desc: '''
                     The signal that connects to the pads TX driver
                '''
                swaccess: "rw"
                hwaccess: "hro"
                resval: "0"
            },
            {
                bits: "2:1"
                name: drv
                desc: '''
                     Driving strength selector
                '''
                swaccess: "rw"
                hwaccess: "hro"
                resval: "3"
            },
            {
                bits: "3"
                name: pde
                desc: '''
                     Pull down resistor enable
                '''
                swaccess: "rw"
                hwaccess: "hro"
                resval: "0"
            },
            {
                bits: "4"
                name: pue
                desc: '''
                     Pull up resistor enable
                '''
                swaccess: "rw"
                hwaccess: "hro"
                resval: "0"
            },
            {
                bits: "5"
                name: rxe
                desc: '''
                     Active high RX driver enable 
                '''
                swaccess: "rw"
                hwaccess: "hro"
                resval: "1"
            },
            {
                bits: "6"
                name: slw
                desc: '''
                     
                '''
                swaccess: "rw"
                hwaccess: "hro"
                resval: "0"
            },
            {
                bits: "7"
                name: smt
                desc: '''
                     Schmit trigger enable
                '''
                swaccess: "rw"
                hwaccess: "hro"
                resval: "0"
            },
            {
                bits: "8"
                name: trie
                desc: '''
                      Active high tri-state enable (active low TX driver enable)
                '''
                swaccess: "rw"
                hwaccess: "hro"
                resval: "1"
            },
          ]
      }

       {
          name: PAD_GPIOB6_MUX_SEL
          desc: '''
              Pad signal port multiplex selection for pad pad_gpiob6. The programmed value defines which port
              is connected to the pad.
          '''
          swaccess: "rw"
          hwaccess: "hro"
          resval: 0
          fields: [
              {
                  name: sel
                  desc: "Port selection index for pad pad_gpiob6."
                  bits: "5:0"
                  enum: [
                      { value: "0", name: "register", desc: "Connects the Pad to the internal configuration register."}
                      { value: "1", name: "port_gpio_b_gpio6", desc: "Connect port gpio6 from port group gpio_b to this pad." }
                      { value: "2", name: "port_qspi0_spi_csn0", desc: "Connect port spi_csn0 from port group qspi0 to this pad." }
                      { value: "3", name: "port_qspi0_spi_csn1", desc: "Connect port spi_csn1 from port group qspi0 to this pad." }
                      { value: "4", name: "port_qspi0_spi_csn2", desc: "Connect port spi_csn2 from port group qspi0 to this pad." }
                      { value: "5", name: "port_qspi0_spi_csn3", desc: "Connect port spi_csn3 from port group qspi0 to this pad." }
                      { value: "6", name: "port_qspi0_spi_sck", desc: "Connect port spi_sck from port group qspi0 to this pad." }
                      { value: "7", name: "port_qspi0_spi_sdio0", desc: "Connect port spi_sdio0 from port group qspi0 to this pad." }
                      { value: "8", name: "port_qspi0_spi_sdio1", desc: "Connect port spi_sdio1 from port group qspi0 to this pad." }
                      { value: "9", name: "port_qspi0_spi_sdio2", desc: "Connect port spi_sdio2 from port group qspi0 to this pad." }
                      { value: "10", name: "port_qspi0_spi_sdio3", desc: "Connect port spi_sdio3 from port group qspi0 to this pad." }
                      { value: "11", name: "port_qspi1_spi_csn0", desc: "Connect port spi_csn0 from port group qspi1 to this pad." }
                      { value: "12", name: "port_qspi1_spi_csn1", desc: "Connect port spi_csn1 from port group qspi1 to this pad." }
                      { value: "13", name: "port_qspi1_spi_csn2", desc: "Connect port spi_csn2 from port group qspi1 to this pad." }
                      { value: "14", name: "port_qspi1_spi_csn3", desc: "Connect port spi_csn3 from port group qspi1 to this pad." }
                      { value: "15", name: "port_qspi1_spi_sck", desc: "Connect port spi_sck from port group qspi1 to this pad." }
                      { value: "16", name: "port_qspi1_spi_sdio0", desc: "Connect port spi_sdio0 from port group qspi1 to this pad." }
                      { value: "17", name: "port_qspi1_spi_sdio1", desc: "Connect port spi_sdio1 from port group qspi1 to this pad." }
                      { value: "18", name: "port_qspi1_spi_sdio2", desc: "Connect port spi_sdio2 from port group qspi1 to this pad." }
                      { value: "19", name: "port_qspi1_spi_sdio3", desc: "Connect port spi_sdio3 from port group qspi1 to this pad." }
                      { value: "20", name: "port_qspi2_spi_csn0", desc: "Connect port spi_csn0 from port group qspi2 to this pad." }
                      { value: "21", name: "port_qspi2_spi_csn1", desc: "Connect port spi_csn1 from port group qspi2 to this pad." }
                      { value: "22", name: "port_qspi2_spi_csn2", desc: "Connect port spi_csn2 from port group qspi2 to this pad." }
                      { value: "23", name: "port_qspi2_spi_csn3", desc: "Connect port spi_csn3 from port group qspi2 to this pad." }
                      { value: "24", name: "port_qspi2_spi_sck", desc: "Connect port spi_sck from port group qspi2 to this pad." }
                      { value: "25", name: "port_qspi2_spi_sdio0", desc: "Connect port spi_sdio0 from port group qspi2 to this pad." }
                      { value: "26", name: "port_qspi2_spi_sdio1", desc: "Connect port spi_sdio1 from port group qspi2 to this pad." }
                      { value: "27", name: "port_qspi2_spi_sdio2", desc: "Connect port spi_sdio2 from port group qspi2 to this pad." }
                      { value: "28", name: "port_qspi2_spi_sdio3", desc: "Connect port spi_sdio3 from port group qspi2 to this pad." }
                      { value: "29", name: "port_qspi3_spi_csn0", desc: "Connect port spi_csn0 from port group qspi3 to this pad." }
                      { value: "30", name: "port_qspi3_spi_csn1", desc: "Connect port spi_csn1 from port group qspi3 to this pad." }
                      { value: "31", name: "port_qspi3_spi_csn2", desc: "Connect port spi_csn2 from port group qspi3 to this pad." }
                      { value: "32", name: "port_qspi3_spi_csn3", desc: "Connect port spi_csn3 from port group qspi3 to this pad." }
                      { value: "33", name: "port_qspi3_spi_sck", desc: "Connect port spi_sck from port group qspi3 to this pad." }
                      { value: "34", name: "port_qspi3_spi_sdio0", desc: "Connect port spi_sdio0 from port group qspi3 to this pad." }
                      { value: "35", name: "port_qspi3_spi_sdio1", desc: "Connect port spi_sdio1 from port group qspi3 to this pad." }
                      { value: "36", name: "port_qspi3_spi_sdio2", desc: "Connect port spi_sdio2 from port group qspi3 to this pad." }
                      { value: "37", name: "port_qspi3_spi_sdio3", desc: "Connect port spi_sdio3 from port group qspi3 to this pad." }
                      { value: "38", name: "port_timer0_out0", desc: "Connect port out0 from port group timer0 to this pad." }
                      { value: "39", name: "port_timer0_out1", desc: "Connect port out1 from port group timer0 to this pad." }
                      { value: "40", name: "port_timer0_out2", desc: "Connect port out2 from port group timer0 to this pad." }
                      { value: "41", name: "port_timer0_out3", desc: "Connect port out3 from port group timer0 to this pad." }
                      { value: "42", name: "port_timer1_out0", desc: "Connect port out0 from port group timer1 to this pad." }
                      { value: "43", name: "port_timer1_out1", desc: "Connect port out1 from port group timer1 to this pad." }
                      { value: "44", name: "port_timer1_out2", desc: "Connect port out2 from port group timer1 to this pad." }
                      { value: "45", name: "port_timer1_out3", desc: "Connect port out3 from port group timer1 to this pad." }
                      { value: "46", name: "port_timer2_out0", desc: "Connect port out0 from port group timer2 to this pad." }
                      { value: "47", name: "port_timer2_out1", desc: "Connect port out1 from port group timer2 to this pad." }
                      { value: "48", name: "port_timer2_out2", desc: "Connect port out2 from port group timer2 to this pad." }
                      { value: "49", name: "port_timer2_out3", desc: "Connect port out3 from port group timer2 to this pad." }
                      { value: "50", name: "port_timer3_out0", desc: "Connect port out0 from port group timer3 to this pad." }
                      { value: "51", name: "port_timer3_out1", desc: "Connect port out1 from port group timer3 to this pad." }
                      { value: "52", name: "port_timer3_out2", desc: "Connect port out2 from port group timer3 to this pad." }
                      { value: "53", name: "port_timer3_out3", desc: "Connect port out3 from port group timer3 to this pad." }
                  ]
              }
          ]
      }

      {
          name: PAD_GPIOB7_CFG
          desc: '''
            Pad signal configuration.
          '''
          swaccess: "rw"
          fields: [
            {
                bits: "0"
                name: chip2pad
                desc: '''
                     The signal that connects to the pads TX driver
                '''
                swaccess: "rw"
                hwaccess: "hro"
                resval: "0"
            },
            {
                bits: "2:1"
                name: drv
                desc: '''
                     Driving strength selector
                '''
                swaccess: "rw"
                hwaccess: "hro"
                resval: "3"
            },
            {
                bits: "3"
                name: pde
                desc: '''
                     Pull down resistor enable
                '''
                swaccess: "rw"
                hwaccess: "hro"
                resval: "0"
            },
            {
                bits: "4"
                name: pue
                desc: '''
                     Pull up resistor enable
                '''
                swaccess: "rw"
                hwaccess: "hro"
                resval: "0"
            },
            {
                bits: "5"
                name: rxe
                desc: '''
                     Active high RX driver enable 
                '''
                swaccess: "rw"
                hwaccess: "hro"
                resval: "1"
            },
            {
                bits: "6"
                name: slw
                desc: '''
                     
                '''
                swaccess: "rw"
                hwaccess: "hro"
                resval: "0"
            },
            {
                bits: "7"
                name: smt
                desc: '''
                     Schmit trigger enable
                '''
                swaccess: "rw"
                hwaccess: "hro"
                resval: "0"
            },
            {
                bits: "8"
                name: trie
                desc: '''
                      Active high tri-state enable (active low TX driver enable)
                '''
                swaccess: "rw"
                hwaccess: "hro"
                resval: "1"
            },
          ]
      }

       {
          name: PAD_GPIOB7_MUX_SEL
          desc: '''
              Pad signal port multiplex selection for pad pad_gpiob7. The programmed value defines which port
              is connected to the pad.
          '''
          swaccess: "rw"
          hwaccess: "hro"
          resval: 0
          fields: [
              {
                  name: sel
                  desc: "Port selection index for pad pad_gpiob7."
                  bits: "5:0"
                  enum: [
                      { value: "0", name: "register", desc: "Connects the Pad to the internal configuration register."}
                      { value: "1", name: "port_gpio_b_gpio7", desc: "Connect port gpio7 from port group gpio_b to this pad." }
                      { value: "2", name: "port_qspi0_spi_csn0", desc: "Connect port spi_csn0 from port group qspi0 to this pad." }
                      { value: "3", name: "port_qspi0_spi_csn1", desc: "Connect port spi_csn1 from port group qspi0 to this pad." }
                      { value: "4", name: "port_qspi0_spi_csn2", desc: "Connect port spi_csn2 from port group qspi0 to this pad." }
                      { value: "5", name: "port_qspi0_spi_csn3", desc: "Connect port spi_csn3 from port group qspi0 to this pad." }
                      { value: "6", name: "port_qspi0_spi_sck", desc: "Connect port spi_sck from port group qspi0 to this pad." }
                      { value: "7", name: "port_qspi0_spi_sdio0", desc: "Connect port spi_sdio0 from port group qspi0 to this pad." }
                      { value: "8", name: "port_qspi0_spi_sdio1", desc: "Connect port spi_sdio1 from port group qspi0 to this pad." }
                      { value: "9", name: "port_qspi0_spi_sdio2", desc: "Connect port spi_sdio2 from port group qspi0 to this pad." }
                      { value: "10", name: "port_qspi0_spi_sdio3", desc: "Connect port spi_sdio3 from port group qspi0 to this pad." }
                      { value: "11", name: "port_qspi1_spi_csn0", desc: "Connect port spi_csn0 from port group qspi1 to this pad." }
                      { value: "12", name: "port_qspi1_spi_csn1", desc: "Connect port spi_csn1 from port group qspi1 to this pad." }
                      { value: "13", name: "port_qspi1_spi_csn2", desc: "Connect port spi_csn2 from port group qspi1 to this pad." }
                      { value: "14", name: "port_qspi1_spi_csn3", desc: "Connect port spi_csn3 from port group qspi1 to this pad." }
                      { value: "15", name: "port_qspi1_spi_sck", desc: "Connect port spi_sck from port group qspi1 to this pad." }
                      { value: "16", name: "port_qspi1_spi_sdio0", desc: "Connect port spi_sdio0 from port group qspi1 to this pad." }
                      { value: "17", name: "port_qspi1_spi_sdio1", desc: "Connect port spi_sdio1 from port group qspi1 to this pad." }
                      { value: "18", name: "port_qspi1_spi_sdio2", desc: "Connect port spi_sdio2 from port group qspi1 to this pad." }
                      { value: "19", name: "port_qspi1_spi_sdio3", desc: "Connect port spi_sdio3 from port group qspi1 to this pad." }
                      { value: "20", name: "port_qspi2_spi_csn0", desc: "Connect port spi_csn0 from port group qspi2 to this pad." }
                      { value: "21", name: "port_qspi2_spi_csn1", desc: "Connect port spi_csn1 from port group qspi2 to this pad." }
                      { value: "22", name: "port_qspi2_spi_csn2", desc: "Connect port spi_csn2 from port group qspi2 to this pad." }
                      { value: "23", name: "port_qspi2_spi_csn3", desc: "Connect port spi_csn3 from port group qspi2 to this pad." }
                      { value: "24", name: "port_qspi2_spi_sck", desc: "Connect port spi_sck from port group qspi2 to this pad." }
                      { value: "25", name: "port_qspi2_spi_sdio0", desc: "Connect port spi_sdio0 from port group qspi2 to this pad." }
                      { value: "26", name: "port_qspi2_spi_sdio1", desc: "Connect port spi_sdio1 from port group qspi2 to this pad." }
                      { value: "27", name: "port_qspi2_spi_sdio2", desc: "Connect port spi_sdio2 from port group qspi2 to this pad." }
                      { value: "28", name: "port_qspi2_spi_sdio3", desc: "Connect port spi_sdio3 from port group qspi2 to this pad." }
                      { value: "29", name: "port_qspi3_spi_csn0", desc: "Connect port spi_csn0 from port group qspi3 to this pad." }
                      { value: "30", name: "port_qspi3_spi_csn1", desc: "Connect port spi_csn1 from port group qspi3 to this pad." }
                      { value: "31", name: "port_qspi3_spi_csn2", desc: "Connect port spi_csn2 from port group qspi3 to this pad." }
                      { value: "32", name: "port_qspi3_spi_csn3", desc: "Connect port spi_csn3 from port group qspi3 to this pad." }
                      { value: "33", name: "port_qspi3_spi_sck", desc: "Connect port spi_sck from port group qspi3 to this pad." }
                      { value: "34", name: "port_qspi3_spi_sdio0", desc: "Connect port spi_sdio0 from port group qspi3 to this pad." }
                      { value: "35", name: "port_qspi3_spi_sdio1", desc: "Connect port spi_sdio1 from port group qspi3 to this pad." }
                      { value: "36", name: "port_qspi3_spi_sdio2", desc: "Connect port spi_sdio2 from port group qspi3 to this pad." }
                      { value: "37", name: "port_qspi3_spi_sdio3", desc: "Connect port spi_sdio3 from port group qspi3 to this pad." }
                      { value: "38", name: "port_timer0_out0", desc: "Connect port out0 from port group timer0 to this pad." }
                      { value: "39", name: "port_timer0_out1", desc: "Connect port out1 from port group timer0 to this pad." }
                      { value: "40", name: "port_timer0_out2", desc: "Connect port out2 from port group timer0 to this pad." }
                      { value: "41", name: "port_timer0_out3", desc: "Connect port out3 from port group timer0 to this pad." }
                      { value: "42", name: "port_timer1_out0", desc: "Connect port out0 from port group timer1 to this pad." }
                      { value: "43", name: "port_timer1_out1", desc: "Connect port out1 from port group timer1 to this pad." }
                      { value: "44", name: "port_timer1_out2", desc: "Connect port out2 from port group timer1 to this pad." }
                      { value: "45", name: "port_timer1_out3", desc: "Connect port out3 from port group timer1 to this pad." }
                      { value: "46", name: "port_timer2_out0", desc: "Connect port out0 from port group timer2 to this pad." }
                      { value: "47", name: "port_timer2_out1", desc: "Connect port out1 from port group timer2 to this pad." }
                      { value: "48", name: "port_timer2_out2", desc: "Connect port out2 from port group timer2 to this pad." }
                      { value: "49", name: "port_timer2_out3", desc: "Connect port out3 from port group timer2 to this pad." }
                      { value: "50", name: "port_timer3_out0", desc: "Connect port out0 from port group timer3 to this pad." }
                      { value: "51", name: "port_timer3_out1", desc: "Connect port out1 from port group timer3 to this pad." }
                      { value: "52", name: "port_timer3_out2", desc: "Connect port out2 from port group timer3 to this pad." }
                      { value: "53", name: "port_timer3_out3", desc: "Connect port out3 from port group timer3 to this pad." }
                  ]
              }
          ]
      }

      {
          name: PAD_GPIOB8_CFG
          desc: '''
            Pad signal configuration.
          '''
          swaccess: "rw"
          fields: [
            {
                bits: "0"
                name: chip2pad
                desc: '''
                     The signal that connects to the pads TX driver
                '''
                swaccess: "rw"
                hwaccess: "hro"
                resval: "0"
            },
            {
                bits: "2:1"
                name: drv
                desc: '''
                     Driving strength selector
                '''
                swaccess: "rw"
                hwaccess: "hro"
                resval: "3"
            },
            {
                bits: "3"
                name: pde
                desc: '''
                     Pull down resistor enable
                '''
                swaccess: "rw"
                hwaccess: "hro"
                resval: "0"
            },
            {
                bits: "4"
                name: pue
                desc: '''
                     Pull up resistor enable
                '''
                swaccess: "rw"
                hwaccess: "hro"
                resval: "0"
            },
            {
                bits: "5"
                name: rxe
                desc: '''
                     Active high RX driver enable 
                '''
                swaccess: "rw"
                hwaccess: "hro"
                resval: "1"
            },
            {
                bits: "6"
                name: slw
                desc: '''
                     
                '''
                swaccess: "rw"
                hwaccess: "hro"
                resval: "0"
            },
            {
                bits: "7"
                name: smt
                desc: '''
                     Schmit trigger enable
                '''
                swaccess: "rw"
                hwaccess: "hro"
                resval: "0"
            },
            {
                bits: "8"
                name: trie
                desc: '''
                      Active high tri-state enable (active low TX driver enable)
                '''
                swaccess: "rw"
                hwaccess: "hro"
                resval: "1"
            },
          ]
      }

       {
          name: PAD_GPIOB8_MUX_SEL
          desc: '''
              Pad signal port multiplex selection for pad pad_gpiob8. The programmed value defines which port
              is connected to the pad.
          '''
          swaccess: "rw"
          hwaccess: "hro"
          resval: 0
          fields: [
              {
                  name: sel
                  desc: "Port selection index for pad pad_gpiob8."
                  bits: "5:0"
                  enum: [
                      { value: "0", name: "register", desc: "Connects the Pad to the internal configuration register."}
                      { value: "1", name: "port_gpio_b_gpio8", desc: "Connect port gpio8 from port group gpio_b to this pad." }
                      { value: "2", name: "port_qspi0_spi_csn0", desc: "Connect port spi_csn0 from port group qspi0 to this pad." }
                      { value: "3", name: "port_qspi0_spi_csn1", desc: "Connect port spi_csn1 from port group qspi0 to this pad." }
                      { value: "4", name: "port_qspi0_spi_csn2", desc: "Connect port spi_csn2 from port group qspi0 to this pad." }
                      { value: "5", name: "port_qspi0_spi_csn3", desc: "Connect port spi_csn3 from port group qspi0 to this pad." }
                      { value: "6", name: "port_qspi0_spi_sck", desc: "Connect port spi_sck from port group qspi0 to this pad." }
                      { value: "7", name: "port_qspi0_spi_sdio0", desc: "Connect port spi_sdio0 from port group qspi0 to this pad." }
                      { value: "8", name: "port_qspi0_spi_sdio1", desc: "Connect port spi_sdio1 from port group qspi0 to this pad." }
                      { value: "9", name: "port_qspi0_spi_sdio2", desc: "Connect port spi_sdio2 from port group qspi0 to this pad." }
                      { value: "10", name: "port_qspi0_spi_sdio3", desc: "Connect port spi_sdio3 from port group qspi0 to this pad." }
                      { value: "11", name: "port_qspi1_spi_csn0", desc: "Connect port spi_csn0 from port group qspi1 to this pad." }
                      { value: "12", name: "port_qspi1_spi_csn1", desc: "Connect port spi_csn1 from port group qspi1 to this pad." }
                      { value: "13", name: "port_qspi1_spi_csn2", desc: "Connect port spi_csn2 from port group qspi1 to this pad." }
                      { value: "14", name: "port_qspi1_spi_csn3", desc: "Connect port spi_csn3 from port group qspi1 to this pad." }
                      { value: "15", name: "port_qspi1_spi_sck", desc: "Connect port spi_sck from port group qspi1 to this pad." }
                      { value: "16", name: "port_qspi1_spi_sdio0", desc: "Connect port spi_sdio0 from port group qspi1 to this pad." }
                      { value: "17", name: "port_qspi1_spi_sdio1", desc: "Connect port spi_sdio1 from port group qspi1 to this pad." }
                      { value: "18", name: "port_qspi1_spi_sdio2", desc: "Connect port spi_sdio2 from port group qspi1 to this pad." }
                      { value: "19", name: "port_qspi1_spi_sdio3", desc: "Connect port spi_sdio3 from port group qspi1 to this pad." }
                      { value: "20", name: "port_qspi2_spi_csn0", desc: "Connect port spi_csn0 from port group qspi2 to this pad." }
                      { value: "21", name: "port_qspi2_spi_csn1", desc: "Connect port spi_csn1 from port group qspi2 to this pad." }
                      { value: "22", name: "port_qspi2_spi_csn2", desc: "Connect port spi_csn2 from port group qspi2 to this pad." }
                      { value: "23", name: "port_qspi2_spi_csn3", desc: "Connect port spi_csn3 from port group qspi2 to this pad." }
                      { value: "24", name: "port_qspi2_spi_sck", desc: "Connect port spi_sck from port group qspi2 to this pad." }
                      { value: "25", name: "port_qspi2_spi_sdio0", desc: "Connect port spi_sdio0 from port group qspi2 to this pad." }
                      { value: "26", name: "port_qspi2_spi_sdio1", desc: "Connect port spi_sdio1 from port group qspi2 to this pad." }
                      { value: "27", name: "port_qspi2_spi_sdio2", desc: "Connect port spi_sdio2 from port group qspi2 to this pad." }
                      { value: "28", name: "port_qspi2_spi_sdio3", desc: "Connect port spi_sdio3 from port group qspi2 to this pad." }
                      { value: "29", name: "port_qspi3_spi_csn0", desc: "Connect port spi_csn0 from port group qspi3 to this pad." }
                      { value: "30", name: "port_qspi3_spi_csn1", desc: "Connect port spi_csn1 from port group qspi3 to this pad." }
                      { value: "31", name: "port_qspi3_spi_csn2", desc: "Connect port spi_csn2 from port group qspi3 to this pad." }
                      { value: "32", name: "port_qspi3_spi_csn3", desc: "Connect port spi_csn3 from port group qspi3 to this pad." }
                      { value: "33", name: "port_qspi3_spi_sck", desc: "Connect port spi_sck from port group qspi3 to this pad." }
                      { value: "34", name: "port_qspi3_spi_sdio0", desc: "Connect port spi_sdio0 from port group qspi3 to this pad." }
                      { value: "35", name: "port_qspi3_spi_sdio1", desc: "Connect port spi_sdio1 from port group qspi3 to this pad." }
                      { value: "36", name: "port_qspi3_spi_sdio2", desc: "Connect port spi_sdio2 from port group qspi3 to this pad." }
                      { value: "37", name: "port_qspi3_spi_sdio3", desc: "Connect port spi_sdio3 from port group qspi3 to this pad." }
                      { value: "38", name: "port_timer0_out0", desc: "Connect port out0 from port group timer0 to this pad." }
                      { value: "39", name: "port_timer0_out1", desc: "Connect port out1 from port group timer0 to this pad." }
                      { value: "40", name: "port_timer0_out2", desc: "Connect port out2 from port group timer0 to this pad." }
                      { value: "41", name: "port_timer0_out3", desc: "Connect port out3 from port group timer0 to this pad." }
                      { value: "42", name: "port_timer1_out0", desc: "Connect port out0 from port group timer1 to this pad." }
                      { value: "43", name: "port_timer1_out1", desc: "Connect port out1 from port group timer1 to this pad." }
                      { value: "44", name: "port_timer1_out2", desc: "Connect port out2 from port group timer1 to this pad." }
                      { value: "45", name: "port_timer1_out3", desc: "Connect port out3 from port group timer1 to this pad." }
                      { value: "46", name: "port_timer2_out0", desc: "Connect port out0 from port group timer2 to this pad." }
                      { value: "47", name: "port_timer2_out1", desc: "Connect port out1 from port group timer2 to this pad." }
                      { value: "48", name: "port_timer2_out2", desc: "Connect port out2 from port group timer2 to this pad." }
                      { value: "49", name: "port_timer2_out3", desc: "Connect port out3 from port group timer2 to this pad." }
                      { value: "50", name: "port_timer3_out0", desc: "Connect port out0 from port group timer3 to this pad." }
                      { value: "51", name: "port_timer3_out1", desc: "Connect port out1 from port group timer3 to this pad." }
                      { value: "52", name: "port_timer3_out2", desc: "Connect port out2 from port group timer3 to this pad." }
                      { value: "53", name: "port_timer3_out3", desc: "Connect port out3 from port group timer3 to this pad." }
                  ]
              }
          ]
      }

      {
          name: PAD_GPIOB9_CFG
          desc: '''
            Pad signal configuration.
          '''
          swaccess: "rw"
          fields: [
            {
                bits: "0"
                name: chip2pad
                desc: '''
                     The signal that connects to the pads TX driver
                '''
                swaccess: "rw"
                hwaccess: "hro"
                resval: "0"
            },
            {
                bits: "2:1"
                name: drv
                desc: '''
                     Driving strength selector
                '''
                swaccess: "rw"
                hwaccess: "hro"
                resval: "3"
            },
            {
                bits: "3"
                name: pde
                desc: '''
                     Pull down resistor enable
                '''
                swaccess: "rw"
                hwaccess: "hro"
                resval: "0"
            },
            {
                bits: "4"
                name: pue
                desc: '''
                     Pull up resistor enable
                '''
                swaccess: "rw"
                hwaccess: "hro"
                resval: "0"
            },
            {
                bits: "5"
                name: rxe
                desc: '''
                     Active high RX driver enable 
                '''
                swaccess: "rw"
                hwaccess: "hro"
                resval: "1"
            },
            {
                bits: "6"
                name: slw
                desc: '''
                     
                '''
                swaccess: "rw"
                hwaccess: "hro"
                resval: "0"
            },
            {
                bits: "7"
                name: smt
                desc: '''
                     Schmit trigger enable
                '''
                swaccess: "rw"
                hwaccess: "hro"
                resval: "0"
            },
            {
                bits: "8"
                name: trie
                desc: '''
                      Active high tri-state enable (active low TX driver enable)
                '''
                swaccess: "rw"
                hwaccess: "hro"
                resval: "1"
            },
          ]
      }

       {
          name: PAD_GPIOB9_MUX_SEL
          desc: '''
              Pad signal port multiplex selection for pad pad_gpiob9. The programmed value defines which port
              is connected to the pad.
          '''
          swaccess: "rw"
          hwaccess: "hro"
          resval: 0
          fields: [
              {
                  name: sel
                  desc: "Port selection index for pad pad_gpiob9."
                  bits: "5:0"
                  enum: [
                      { value: "0", name: "register", desc: "Connects the Pad to the internal configuration register."}
                      { value: "1", name: "port_gpio_b_gpio9", desc: "Connect port gpio9 from port group gpio_b to this pad." }
                      { value: "2", name: "port_qspi0_spi_csn0", desc: "Connect port spi_csn0 from port group qspi0 to this pad." }
                      { value: "3", name: "port_qspi0_spi_csn1", desc: "Connect port spi_csn1 from port group qspi0 to this pad." }
                      { value: "4", name: "port_qspi0_spi_csn2", desc: "Connect port spi_csn2 from port group qspi0 to this pad." }
                      { value: "5", name: "port_qspi0_spi_csn3", desc: "Connect port spi_csn3 from port group qspi0 to this pad." }
                      { value: "6", name: "port_qspi0_spi_sck", desc: "Connect port spi_sck from port group qspi0 to this pad." }
                      { value: "7", name: "port_qspi0_spi_sdio0", desc: "Connect port spi_sdio0 from port group qspi0 to this pad." }
                      { value: "8", name: "port_qspi0_spi_sdio1", desc: "Connect port spi_sdio1 from port group qspi0 to this pad." }
                      { value: "9", name: "port_qspi0_spi_sdio2", desc: "Connect port spi_sdio2 from port group qspi0 to this pad." }
                      { value: "10", name: "port_qspi0_spi_sdio3", desc: "Connect port spi_sdio3 from port group qspi0 to this pad." }
                      { value: "11", name: "port_qspi1_spi_csn0", desc: "Connect port spi_csn0 from port group qspi1 to this pad." }
                      { value: "12", name: "port_qspi1_spi_csn1", desc: "Connect port spi_csn1 from port group qspi1 to this pad." }
                      { value: "13", name: "port_qspi1_spi_csn2", desc: "Connect port spi_csn2 from port group qspi1 to this pad." }
                      { value: "14", name: "port_qspi1_spi_csn3", desc: "Connect port spi_csn3 from port group qspi1 to this pad." }
                      { value: "15", name: "port_qspi1_spi_sck", desc: "Connect port spi_sck from port group qspi1 to this pad." }
                      { value: "16", name: "port_qspi1_spi_sdio0", desc: "Connect port spi_sdio0 from port group qspi1 to this pad." }
                      { value: "17", name: "port_qspi1_spi_sdio1", desc: "Connect port spi_sdio1 from port group qspi1 to this pad." }
                      { value: "18", name: "port_qspi1_spi_sdio2", desc: "Connect port spi_sdio2 from port group qspi1 to this pad." }
                      { value: "19", name: "port_qspi1_spi_sdio3", desc: "Connect port spi_sdio3 from port group qspi1 to this pad." }
                      { value: "20", name: "port_qspi2_spi_csn0", desc: "Connect port spi_csn0 from port group qspi2 to this pad." }
                      { value: "21", name: "port_qspi2_spi_csn1", desc: "Connect port spi_csn1 from port group qspi2 to this pad." }
                      { value: "22", name: "port_qspi2_spi_csn2", desc: "Connect port spi_csn2 from port group qspi2 to this pad." }
                      { value: "23", name: "port_qspi2_spi_csn3", desc: "Connect port spi_csn3 from port group qspi2 to this pad." }
                      { value: "24", name: "port_qspi2_spi_sck", desc: "Connect port spi_sck from port group qspi2 to this pad." }
                      { value: "25", name: "port_qspi2_spi_sdio0", desc: "Connect port spi_sdio0 from port group qspi2 to this pad." }
                      { value: "26", name: "port_qspi2_spi_sdio1", desc: "Connect port spi_sdio1 from port group qspi2 to this pad." }
                      { value: "27", name: "port_qspi2_spi_sdio2", desc: "Connect port spi_sdio2 from port group qspi2 to this pad." }
                      { value: "28", name: "port_qspi2_spi_sdio3", desc: "Connect port spi_sdio3 from port group qspi2 to this pad." }
                      { value: "29", name: "port_qspi3_spi_csn0", desc: "Connect port spi_csn0 from port group qspi3 to this pad." }
                      { value: "30", name: "port_qspi3_spi_csn1", desc: "Connect port spi_csn1 from port group qspi3 to this pad." }
                      { value: "31", name: "port_qspi3_spi_csn2", desc: "Connect port spi_csn2 from port group qspi3 to this pad." }
                      { value: "32", name: "port_qspi3_spi_csn3", desc: "Connect port spi_csn3 from port group qspi3 to this pad." }
                      { value: "33", name: "port_qspi3_spi_sck", desc: "Connect port spi_sck from port group qspi3 to this pad." }
                      { value: "34", name: "port_qspi3_spi_sdio0", desc: "Connect port spi_sdio0 from port group qspi3 to this pad." }
                      { value: "35", name: "port_qspi3_spi_sdio1", desc: "Connect port spi_sdio1 from port group qspi3 to this pad." }
                      { value: "36", name: "port_qspi3_spi_sdio2", desc: "Connect port spi_sdio2 from port group qspi3 to this pad." }
                      { value: "37", name: "port_qspi3_spi_sdio3", desc: "Connect port spi_sdio3 from port group qspi3 to this pad." }
                      { value: "38", name: "port_timer0_out0", desc: "Connect port out0 from port group timer0 to this pad." }
                      { value: "39", name: "port_timer0_out1", desc: "Connect port out1 from port group timer0 to this pad." }
                      { value: "40", name: "port_timer0_out2", desc: "Connect port out2 from port group timer0 to this pad." }
                      { value: "41", name: "port_timer0_out3", desc: "Connect port out3 from port group timer0 to this pad." }
                      { value: "42", name: "port_timer1_out0", desc: "Connect port out0 from port group timer1 to this pad." }
                      { value: "43", name: "port_timer1_out1", desc: "Connect port out1 from port group timer1 to this pad." }
                      { value: "44", name: "port_timer1_out2", desc: "Connect port out2 from port group timer1 to this pad." }
                      { value: "45", name: "port_timer1_out3", desc: "Connect port out3 from port group timer1 to this pad." }
                      { value: "46", name: "port_timer2_out0", desc: "Connect port out0 from port group timer2 to this pad." }
                      { value: "47", name: "port_timer2_out1", desc: "Connect port out1 from port group timer2 to this pad." }
                      { value: "48", name: "port_timer2_out2", desc: "Connect port out2 from port group timer2 to this pad." }
                      { value: "49", name: "port_timer2_out3", desc: "Connect port out3 from port group timer2 to this pad." }
                      { value: "50", name: "port_timer3_out0", desc: "Connect port out0 from port group timer3 to this pad." }
                      { value: "51", name: "port_timer3_out1", desc: "Connect port out1 from port group timer3 to this pad." }
                      { value: "52", name: "port_timer3_out2", desc: "Connect port out2 from port group timer3 to this pad." }
                      { value: "53", name: "port_timer3_out3", desc: "Connect port out3 from port group timer3 to this pad." }
                  ]
              }
          ]
      }

      {
          name: PAD_GPIOB10_CFG
          desc: '''
            Pad signal configuration.
          '''
          swaccess: "rw"
          fields: [
            {
                bits: "0"
                name: chip2pad
                desc: '''
                     The signal that connects to the pads TX driver
                '''
                swaccess: "rw"
                hwaccess: "hro"
                resval: "0"
            },
            {
                bits: "2:1"
                name: drv
                desc: '''
                     Driving strength selector
                '''
                swaccess: "rw"
                hwaccess: "hro"
                resval: "3"
            },
            {
                bits: "3"
                name: pde
                desc: '''
                     Pull down resistor enable
                '''
                swaccess: "rw"
                hwaccess: "hro"
                resval: "0"
            },
            {
                bits: "4"
                name: pue
                desc: '''
                     Pull up resistor enable
                '''
                swaccess: "rw"
                hwaccess: "hro"
                resval: "0"
            },
            {
                bits: "5"
                name: rxe
                desc: '''
                     Active high RX driver enable 
                '''
                swaccess: "rw"
                hwaccess: "hro"
                resval: "1"
            },
            {
                bits: "6"
                name: slw
                desc: '''
                     
                '''
                swaccess: "rw"
                hwaccess: "hro"
                resval: "0"
            },
            {
                bits: "7"
                name: smt
                desc: '''
                     Schmit trigger enable
                '''
                swaccess: "rw"
                hwaccess: "hro"
                resval: "0"
            },
            {
                bits: "8"
                name: trie
                desc: '''
                      Active high tri-state enable (active low TX driver enable)
                '''
                swaccess: "rw"
                hwaccess: "hro"
                resval: "1"
            },
          ]
      }

       {
          name: PAD_GPIOB10_MUX_SEL
          desc: '''
              Pad signal port multiplex selection for pad pad_gpiob10. The programmed value defines which port
              is connected to the pad.
          '''
          swaccess: "rw"
          hwaccess: "hro"
          resval: 0
          fields: [
              {
                  name: sel
                  desc: "Port selection index for pad pad_gpiob10."
                  bits: "5:0"
                  enum: [
                      { value: "0", name: "register", desc: "Connects the Pad to the internal configuration register."}
                      { value: "1", name: "port_gpio_b_gpio10", desc: "Connect port gpio10 from port group gpio_b to this pad." }
                      { value: "2", name: "port_qspi0_spi_csn0", desc: "Connect port spi_csn0 from port group qspi0 to this pad." }
                      { value: "3", name: "port_qspi0_spi_csn1", desc: "Connect port spi_csn1 from port group qspi0 to this pad." }
                      { value: "4", name: "port_qspi0_spi_csn2", desc: "Connect port spi_csn2 from port group qspi0 to this pad." }
                      { value: "5", name: "port_qspi0_spi_csn3", desc: "Connect port spi_csn3 from port group qspi0 to this pad." }
                      { value: "6", name: "port_qspi0_spi_sck", desc: "Connect port spi_sck from port group qspi0 to this pad." }
                      { value: "7", name: "port_qspi0_spi_sdio0", desc: "Connect port spi_sdio0 from port group qspi0 to this pad." }
                      { value: "8", name: "port_qspi0_spi_sdio1", desc: "Connect port spi_sdio1 from port group qspi0 to this pad." }
                      { value: "9", name: "port_qspi0_spi_sdio2", desc: "Connect port spi_sdio2 from port group qspi0 to this pad." }
                      { value: "10", name: "port_qspi0_spi_sdio3", desc: "Connect port spi_sdio3 from port group qspi0 to this pad." }
                      { value: "11", name: "port_qspi1_spi_csn0", desc: "Connect port spi_csn0 from port group qspi1 to this pad." }
                      { value: "12", name: "port_qspi1_spi_csn1", desc: "Connect port spi_csn1 from port group qspi1 to this pad." }
                      { value: "13", name: "port_qspi1_spi_csn2", desc: "Connect port spi_csn2 from port group qspi1 to this pad." }
                      { value: "14", name: "port_qspi1_spi_csn3", desc: "Connect port spi_csn3 from port group qspi1 to this pad." }
                      { value: "15", name: "port_qspi1_spi_sck", desc: "Connect port spi_sck from port group qspi1 to this pad." }
                      { value: "16", name: "port_qspi1_spi_sdio0", desc: "Connect port spi_sdio0 from port group qspi1 to this pad." }
                      { value: "17", name: "port_qspi1_spi_sdio1", desc: "Connect port spi_sdio1 from port group qspi1 to this pad." }
                      { value: "18", name: "port_qspi1_spi_sdio2", desc: "Connect port spi_sdio2 from port group qspi1 to this pad." }
                      { value: "19", name: "port_qspi1_spi_sdio3", desc: "Connect port spi_sdio3 from port group qspi1 to this pad." }
                      { value: "20", name: "port_qspi2_spi_csn0", desc: "Connect port spi_csn0 from port group qspi2 to this pad." }
                      { value: "21", name: "port_qspi2_spi_csn1", desc: "Connect port spi_csn1 from port group qspi2 to this pad." }
                      { value: "22", name: "port_qspi2_spi_csn2", desc: "Connect port spi_csn2 from port group qspi2 to this pad." }
                      { value: "23", name: "port_qspi2_spi_csn3", desc: "Connect port spi_csn3 from port group qspi2 to this pad." }
                      { value: "24", name: "port_qspi2_spi_sck", desc: "Connect port spi_sck from port group qspi2 to this pad." }
                      { value: "25", name: "port_qspi2_spi_sdio0", desc: "Connect port spi_sdio0 from port group qspi2 to this pad." }
                      { value: "26", name: "port_qspi2_spi_sdio1", desc: "Connect port spi_sdio1 from port group qspi2 to this pad." }
                      { value: "27", name: "port_qspi2_spi_sdio2", desc: "Connect port spi_sdio2 from port group qspi2 to this pad." }
                      { value: "28", name: "port_qspi2_spi_sdio3", desc: "Connect port spi_sdio3 from port group qspi2 to this pad." }
                      { value: "29", name: "port_qspi3_spi_csn0", desc: "Connect port spi_csn0 from port group qspi3 to this pad." }
                      { value: "30", name: "port_qspi3_spi_csn1", desc: "Connect port spi_csn1 from port group qspi3 to this pad." }
                      { value: "31", name: "port_qspi3_spi_csn2", desc: "Connect port spi_csn2 from port group qspi3 to this pad." }
                      { value: "32", name: "port_qspi3_spi_csn3", desc: "Connect port spi_csn3 from port group qspi3 to this pad." }
                      { value: "33", name: "port_qspi3_spi_sck", desc: "Connect port spi_sck from port group qspi3 to this pad." }
                      { value: "34", name: "port_qspi3_spi_sdio0", desc: "Connect port spi_sdio0 from port group qspi3 to this pad." }
                      { value: "35", name: "port_qspi3_spi_sdio1", desc: "Connect port spi_sdio1 from port group qspi3 to this pad." }
                      { value: "36", name: "port_qspi3_spi_sdio2", desc: "Connect port spi_sdio2 from port group qspi3 to this pad." }
                      { value: "37", name: "port_qspi3_spi_sdio3", desc: "Connect port spi_sdio3 from port group qspi3 to this pad." }
                      { value: "38", name: "port_timer0_out0", desc: "Connect port out0 from port group timer0 to this pad." }
                      { value: "39", name: "port_timer0_out1", desc: "Connect port out1 from port group timer0 to this pad." }
                      { value: "40", name: "port_timer0_out2", desc: "Connect port out2 from port group timer0 to this pad." }
                      { value: "41", name: "port_timer0_out3", desc: "Connect port out3 from port group timer0 to this pad." }
                      { value: "42", name: "port_timer1_out0", desc: "Connect port out0 from port group timer1 to this pad." }
                      { value: "43", name: "port_timer1_out1", desc: "Connect port out1 from port group timer1 to this pad." }
                      { value: "44", name: "port_timer1_out2", desc: "Connect port out2 from port group timer1 to this pad." }
                      { value: "45", name: "port_timer1_out3", desc: "Connect port out3 from port group timer1 to this pad." }
                      { value: "46", name: "port_timer2_out0", desc: "Connect port out0 from port group timer2 to this pad." }
                      { value: "47", name: "port_timer2_out1", desc: "Connect port out1 from port group timer2 to this pad." }
                      { value: "48", name: "port_timer2_out2", desc: "Connect port out2 from port group timer2 to this pad." }
                      { value: "49", name: "port_timer2_out3", desc: "Connect port out3 from port group timer2 to this pad." }
                      { value: "50", name: "port_timer3_out0", desc: "Connect port out0 from port group timer3 to this pad." }
                      { value: "51", name: "port_timer3_out1", desc: "Connect port out1 from port group timer3 to this pad." }
                      { value: "52", name: "port_timer3_out2", desc: "Connect port out2 from port group timer3 to this pad." }
                      { value: "53", name: "port_timer3_out3", desc: "Connect port out3 from port group timer3 to this pad." }
                  ]
              }
          ]
      }

      {
          name: PAD_GPIOB11_CFG
          desc: '''
            Pad signal configuration.
          '''
          swaccess: "rw"
          fields: [
            {
                bits: "0"
                name: chip2pad
                desc: '''
                     The signal that connects to the pads TX driver
                '''
                swaccess: "rw"
                hwaccess: "hro"
                resval: "0"
            },
            {
                bits: "2:1"
                name: drv
                desc: '''
                     Driving strength selector
                '''
                swaccess: "rw"
                hwaccess: "hro"
                resval: "3"
            },
            {
                bits: "3"
                name: pde
                desc: '''
                     Pull down resistor enable
                '''
                swaccess: "rw"
                hwaccess: "hro"
                resval: "0"
            },
            {
                bits: "4"
                name: pue
                desc: '''
                     Pull up resistor enable
                '''
                swaccess: "rw"
                hwaccess: "hro"
                resval: "0"
            },
            {
                bits: "5"
                name: rxe
                desc: '''
                     Active high RX driver enable 
                '''
                swaccess: "rw"
                hwaccess: "hro"
                resval: "1"
            },
            {
                bits: "6"
                name: slw
                desc: '''
                     
                '''
                swaccess: "rw"
                hwaccess: "hro"
                resval: "0"
            },
            {
                bits: "7"
                name: smt
                desc: '''
                     Schmit trigger enable
                '''
                swaccess: "rw"
                hwaccess: "hro"
                resval: "0"
            },
            {
                bits: "8"
                name: trie
                desc: '''
                      Active high tri-state enable (active low TX driver enable)
                '''
                swaccess: "rw"
                hwaccess: "hro"
                resval: "1"
            },
          ]
      }

       {
          name: PAD_GPIOB11_MUX_SEL
          desc: '''
              Pad signal port multiplex selection for pad pad_gpiob11. The programmed value defines which port
              is connected to the pad.
          '''
          swaccess: "rw"
          hwaccess: "hro"
          resval: 0
          fields: [
              {
                  name: sel
                  desc: "Port selection index for pad pad_gpiob11."
                  bits: "5:0"
                  enum: [
                      { value: "0", name: "register", desc: "Connects the Pad to the internal configuration register."}
                      { value: "1", name: "port_gpio_b_gpio11", desc: "Connect port gpio11 from port group gpio_b to this pad." }
                      { value: "2", name: "port_qspi0_spi_csn0", desc: "Connect port spi_csn0 from port group qspi0 to this pad." }
                      { value: "3", name: "port_qspi0_spi_csn1", desc: "Connect port spi_csn1 from port group qspi0 to this pad." }
                      { value: "4", name: "port_qspi0_spi_csn2", desc: "Connect port spi_csn2 from port group qspi0 to this pad." }
                      { value: "5", name: "port_qspi0_spi_csn3", desc: "Connect port spi_csn3 from port group qspi0 to this pad." }
                      { value: "6", name: "port_qspi0_spi_sck", desc: "Connect port spi_sck from port group qspi0 to this pad." }
                      { value: "7", name: "port_qspi0_spi_sdio0", desc: "Connect port spi_sdio0 from port group qspi0 to this pad." }
                      { value: "8", name: "port_qspi0_spi_sdio1", desc: "Connect port spi_sdio1 from port group qspi0 to this pad." }
                      { value: "9", name: "port_qspi0_spi_sdio2", desc: "Connect port spi_sdio2 from port group qspi0 to this pad." }
                      { value: "10", name: "port_qspi0_spi_sdio3", desc: "Connect port spi_sdio3 from port group qspi0 to this pad." }
                      { value: "11", name: "port_qspi1_spi_csn0", desc: "Connect port spi_csn0 from port group qspi1 to this pad." }
                      { value: "12", name: "port_qspi1_spi_csn1", desc: "Connect port spi_csn1 from port group qspi1 to this pad." }
                      { value: "13", name: "port_qspi1_spi_csn2", desc: "Connect port spi_csn2 from port group qspi1 to this pad." }
                      { value: "14", name: "port_qspi1_spi_csn3", desc: "Connect port spi_csn3 from port group qspi1 to this pad." }
                      { value: "15", name: "port_qspi1_spi_sck", desc: "Connect port spi_sck from port group qspi1 to this pad." }
                      { value: "16", name: "port_qspi1_spi_sdio0", desc: "Connect port spi_sdio0 from port group qspi1 to this pad." }
                      { value: "17", name: "port_qspi1_spi_sdio1", desc: "Connect port spi_sdio1 from port group qspi1 to this pad." }
                      { value: "18", name: "port_qspi1_spi_sdio2", desc: "Connect port spi_sdio2 from port group qspi1 to this pad." }
                      { value: "19", name: "port_qspi1_spi_sdio3", desc: "Connect port spi_sdio3 from port group qspi1 to this pad." }
                      { value: "20", name: "port_qspi2_spi_csn0", desc: "Connect port spi_csn0 from port group qspi2 to this pad." }
                      { value: "21", name: "port_qspi2_spi_csn1", desc: "Connect port spi_csn1 from port group qspi2 to this pad." }
                      { value: "22", name: "port_qspi2_spi_csn2", desc: "Connect port spi_csn2 from port group qspi2 to this pad." }
                      { value: "23", name: "port_qspi2_spi_csn3", desc: "Connect port spi_csn3 from port group qspi2 to this pad." }
                      { value: "24", name: "port_qspi2_spi_sck", desc: "Connect port spi_sck from port group qspi2 to this pad." }
                      { value: "25", name: "port_qspi2_spi_sdio0", desc: "Connect port spi_sdio0 from port group qspi2 to this pad." }
                      { value: "26", name: "port_qspi2_spi_sdio1", desc: "Connect port spi_sdio1 from port group qspi2 to this pad." }
                      { value: "27", name: "port_qspi2_spi_sdio2", desc: "Connect port spi_sdio2 from port group qspi2 to this pad." }
                      { value: "28", name: "port_qspi2_spi_sdio3", desc: "Connect port spi_sdio3 from port group qspi2 to this pad." }
                      { value: "29", name: "port_qspi3_spi_csn0", desc: "Connect port spi_csn0 from port group qspi3 to this pad." }
                      { value: "30", name: "port_qspi3_spi_csn1", desc: "Connect port spi_csn1 from port group qspi3 to this pad." }
                      { value: "31", name: "port_qspi3_spi_csn2", desc: "Connect port spi_csn2 from port group qspi3 to this pad." }
                      { value: "32", name: "port_qspi3_spi_csn3", desc: "Connect port spi_csn3 from port group qspi3 to this pad." }
                      { value: "33", name: "port_qspi3_spi_sck", desc: "Connect port spi_sck from port group qspi3 to this pad." }
                      { value: "34", name: "port_qspi3_spi_sdio0", desc: "Connect port spi_sdio0 from port group qspi3 to this pad." }
                      { value: "35", name: "port_qspi3_spi_sdio1", desc: "Connect port spi_sdio1 from port group qspi3 to this pad." }
                      { value: "36", name: "port_qspi3_spi_sdio2", desc: "Connect port spi_sdio2 from port group qspi3 to this pad." }
                      { value: "37", name: "port_qspi3_spi_sdio3", desc: "Connect port spi_sdio3 from port group qspi3 to this pad." }
                      { value: "38", name: "port_timer0_out0", desc: "Connect port out0 from port group timer0 to this pad." }
                      { value: "39", name: "port_timer0_out1", desc: "Connect port out1 from port group timer0 to this pad." }
                      { value: "40", name: "port_timer0_out2", desc: "Connect port out2 from port group timer0 to this pad." }
                      { value: "41", name: "port_timer0_out3", desc: "Connect port out3 from port group timer0 to this pad." }
                      { value: "42", name: "port_timer1_out0", desc: "Connect port out0 from port group timer1 to this pad." }
                      { value: "43", name: "port_timer1_out1", desc: "Connect port out1 from port group timer1 to this pad." }
                      { value: "44", name: "port_timer1_out2", desc: "Connect port out2 from port group timer1 to this pad." }
                      { value: "45", name: "port_timer1_out3", desc: "Connect port out3 from port group timer1 to this pad." }
                      { value: "46", name: "port_timer2_out0", desc: "Connect port out0 from port group timer2 to this pad." }
                      { value: "47", name: "port_timer2_out1", desc: "Connect port out1 from port group timer2 to this pad." }
                      { value: "48", name: "port_timer2_out2", desc: "Connect port out2 from port group timer2 to this pad." }
                      { value: "49", name: "port_timer2_out3", desc: "Connect port out3 from port group timer2 to this pad." }
                      { value: "50", name: "port_timer3_out0", desc: "Connect port out0 from port group timer3 to this pad." }
                      { value: "51", name: "port_timer3_out1", desc: "Connect port out1 from port group timer3 to this pad." }
                      { value: "52", name: "port_timer3_out2", desc: "Connect port out2 from port group timer3 to this pad." }
                      { value: "53", name: "port_timer3_out3", desc: "Connect port out3 from port group timer3 to this pad." }
                  ]
              }
          ]
      }

      {
          name: PAD_GPIOB12_CFG
          desc: '''
            Pad signal configuration.
          '''
          swaccess: "rw"
          fields: [
            {
                bits: "0"
                name: chip2pad
                desc: '''
                     The signal that connects to the pads TX driver
                '''
                swaccess: "rw"
                hwaccess: "hro"
                resval: "0"
            },
            {
                bits: "2:1"
                name: drv
                desc: '''
                     Driving strength selector
                '''
                swaccess: "rw"
                hwaccess: "hro"
                resval: "3"
            },
            {
                bits: "3"
                name: pde
                desc: '''
                     Pull down resistor enable
                '''
                swaccess: "rw"
                hwaccess: "hro"
                resval: "0"
            },
            {
                bits: "4"
                name: pue
                desc: '''
                     Pull up resistor enable
                '''
                swaccess: "rw"
                hwaccess: "hro"
                resval: "0"
            },
            {
                bits: "5"
                name: rxe
                desc: '''
                     Active high RX driver enable 
                '''
                swaccess: "rw"
                hwaccess: "hro"
                resval: "1"
            },
            {
                bits: "6"
                name: slw
                desc: '''
                     
                '''
                swaccess: "rw"
                hwaccess: "hro"
                resval: "0"
            },
            {
                bits: "7"
                name: smt
                desc: '''
                     Schmit trigger enable
                '''
                swaccess: "rw"
                hwaccess: "hro"
                resval: "0"
            },
            {
                bits: "8"
                name: trie
                desc: '''
                      Active high tri-state enable (active low TX driver enable)
                '''
                swaccess: "rw"
                hwaccess: "hro"
                resval: "1"
            },
          ]
      }

       {
          name: PAD_GPIOB12_MUX_SEL
          desc: '''
              Pad signal port multiplex selection for pad pad_gpiob12. The programmed value defines which port
              is connected to the pad.
          '''
          swaccess: "rw"
          hwaccess: "hro"
          resval: 0
          fields: [
              {
                  name: sel
                  desc: "Port selection index for pad pad_gpiob12."
                  bits: "5:0"
                  enum: [
                      { value: "0", name: "register", desc: "Connects the Pad to the internal configuration register."}
                      { value: "1", name: "port_gpio_b_gpio12", desc: "Connect port gpio12 from port group gpio_b to this pad." }
                      { value: "2", name: "port_qspi0_spi_csn0", desc: "Connect port spi_csn0 from port group qspi0 to this pad." }
                      { value: "3", name: "port_qspi0_spi_csn1", desc: "Connect port spi_csn1 from port group qspi0 to this pad." }
                      { value: "4", name: "port_qspi0_spi_csn2", desc: "Connect port spi_csn2 from port group qspi0 to this pad." }
                      { value: "5", name: "port_qspi0_spi_csn3", desc: "Connect port spi_csn3 from port group qspi0 to this pad." }
                      { value: "6", name: "port_qspi0_spi_sck", desc: "Connect port spi_sck from port group qspi0 to this pad." }
                      { value: "7", name: "port_qspi0_spi_sdio0", desc: "Connect port spi_sdio0 from port group qspi0 to this pad." }
                      { value: "8", name: "port_qspi0_spi_sdio1", desc: "Connect port spi_sdio1 from port group qspi0 to this pad." }
                      { value: "9", name: "port_qspi0_spi_sdio2", desc: "Connect port spi_sdio2 from port group qspi0 to this pad." }
                      { value: "10", name: "port_qspi0_spi_sdio3", desc: "Connect port spi_sdio3 from port group qspi0 to this pad." }
                      { value: "11", name: "port_qspi1_spi_csn0", desc: "Connect port spi_csn0 from port group qspi1 to this pad." }
                      { value: "12", name: "port_qspi1_spi_csn1", desc: "Connect port spi_csn1 from port group qspi1 to this pad." }
                      { value: "13", name: "port_qspi1_spi_csn2", desc: "Connect port spi_csn2 from port group qspi1 to this pad." }
                      { value: "14", name: "port_qspi1_spi_csn3", desc: "Connect port spi_csn3 from port group qspi1 to this pad." }
                      { value: "15", name: "port_qspi1_spi_sck", desc: "Connect port spi_sck from port group qspi1 to this pad." }
                      { value: "16", name: "port_qspi1_spi_sdio0", desc: "Connect port spi_sdio0 from port group qspi1 to this pad." }
                      { value: "17", name: "port_qspi1_spi_sdio1", desc: "Connect port spi_sdio1 from port group qspi1 to this pad." }
                      { value: "18", name: "port_qspi1_spi_sdio2", desc: "Connect port spi_sdio2 from port group qspi1 to this pad." }
                      { value: "19", name: "port_qspi1_spi_sdio3", desc: "Connect port spi_sdio3 from port group qspi1 to this pad." }
                      { value: "20", name: "port_qspi2_spi_csn0", desc: "Connect port spi_csn0 from port group qspi2 to this pad." }
                      { value: "21", name: "port_qspi2_spi_csn1", desc: "Connect port spi_csn1 from port group qspi2 to this pad." }
                      { value: "22", name: "port_qspi2_spi_csn2", desc: "Connect port spi_csn2 from port group qspi2 to this pad." }
                      { value: "23", name: "port_qspi2_spi_csn3", desc: "Connect port spi_csn3 from port group qspi2 to this pad." }
                      { value: "24", name: "port_qspi2_spi_sck", desc: "Connect port spi_sck from port group qspi2 to this pad." }
                      { value: "25", name: "port_qspi2_spi_sdio0", desc: "Connect port spi_sdio0 from port group qspi2 to this pad." }
                      { value: "26", name: "port_qspi2_spi_sdio1", desc: "Connect port spi_sdio1 from port group qspi2 to this pad." }
                      { value: "27", name: "port_qspi2_spi_sdio2", desc: "Connect port spi_sdio2 from port group qspi2 to this pad." }
                      { value: "28", name: "port_qspi2_spi_sdio3", desc: "Connect port spi_sdio3 from port group qspi2 to this pad." }
                      { value: "29", name: "port_qspi3_spi_csn0", desc: "Connect port spi_csn0 from port group qspi3 to this pad." }
                      { value: "30", name: "port_qspi3_spi_csn1", desc: "Connect port spi_csn1 from port group qspi3 to this pad." }
                      { value: "31", name: "port_qspi3_spi_csn2", desc: "Connect port spi_csn2 from port group qspi3 to this pad." }
                      { value: "32", name: "port_qspi3_spi_csn3", desc: "Connect port spi_csn3 from port group qspi3 to this pad." }
                      { value: "33", name: "port_qspi3_spi_sck", desc: "Connect port spi_sck from port group qspi3 to this pad." }
                      { value: "34", name: "port_qspi3_spi_sdio0", desc: "Connect port spi_sdio0 from port group qspi3 to this pad." }
                      { value: "35", name: "port_qspi3_spi_sdio1", desc: "Connect port spi_sdio1 from port group qspi3 to this pad." }
                      { value: "36", name: "port_qspi3_spi_sdio2", desc: "Connect port spi_sdio2 from port group qspi3 to this pad." }
                      { value: "37", name: "port_qspi3_spi_sdio3", desc: "Connect port spi_sdio3 from port group qspi3 to this pad." }
                      { value: "38", name: "port_timer0_out0", desc: "Connect port out0 from port group timer0 to this pad." }
                      { value: "39", name: "port_timer0_out1", desc: "Connect port out1 from port group timer0 to this pad." }
                      { value: "40", name: "port_timer0_out2", desc: "Connect port out2 from port group timer0 to this pad." }
                      { value: "41", name: "port_timer0_out3", desc: "Connect port out3 from port group timer0 to this pad." }
                      { value: "42", name: "port_timer1_out0", desc: "Connect port out0 from port group timer1 to this pad." }
                      { value: "43", name: "port_timer1_out1", desc: "Connect port out1 from port group timer1 to this pad." }
                      { value: "44", name: "port_timer1_out2", desc: "Connect port out2 from port group timer1 to this pad." }
                      { value: "45", name: "port_timer1_out3", desc: "Connect port out3 from port group timer1 to this pad." }
                      { value: "46", name: "port_timer2_out0", desc: "Connect port out0 from port group timer2 to this pad." }
                      { value: "47", name: "port_timer2_out1", desc: "Connect port out1 from port group timer2 to this pad." }
                      { value: "48", name: "port_timer2_out2", desc: "Connect port out2 from port group timer2 to this pad." }
                      { value: "49", name: "port_timer2_out3", desc: "Connect port out3 from port group timer2 to this pad." }
                      { value: "50", name: "port_timer3_out0", desc: "Connect port out0 from port group timer3 to this pad." }
                      { value: "51", name: "port_timer3_out1", desc: "Connect port out1 from port group timer3 to this pad." }
                      { value: "52", name: "port_timer3_out2", desc: "Connect port out2 from port group timer3 to this pad." }
                      { value: "53", name: "port_timer3_out3", desc: "Connect port out3 from port group timer3 to this pad." }
                  ]
              }
          ]
      }

      {
          name: PAD_GPIOB13_CFG
          desc: '''
            Pad signal configuration.
          '''
          swaccess: "rw"
          fields: [
            {
                bits: "0"
                name: chip2pad
                desc: '''
                     The signal that connects to the pads TX driver
                '''
                swaccess: "rw"
                hwaccess: "hro"
                resval: "0"
            },
            {
                bits: "2:1"
                name: drv
                desc: '''
                     Driving strength selector
                '''
                swaccess: "rw"
                hwaccess: "hro"
                resval: "3"
            },
            {
                bits: "3"
                name: pde
                desc: '''
                     Pull down resistor enable
                '''
                swaccess: "rw"
                hwaccess: "hro"
                resval: "0"
            },
            {
                bits: "4"
                name: pue
                desc: '''
                     Pull up resistor enable
                '''
                swaccess: "rw"
                hwaccess: "hro"
                resval: "0"
            },
            {
                bits: "5"
                name: rxe
                desc: '''
                     Active high RX driver enable 
                '''
                swaccess: "rw"
                hwaccess: "hro"
                resval: "1"
            },
            {
                bits: "6"
                name: slw
                desc: '''
                     
                '''
                swaccess: "rw"
                hwaccess: "hro"
                resval: "0"
            },
            {
                bits: "7"
                name: smt
                desc: '''
                     Schmit trigger enable
                '''
                swaccess: "rw"
                hwaccess: "hro"
                resval: "0"
            },
            {
                bits: "8"
                name: trie
                desc: '''
                      Active high tri-state enable (active low TX driver enable)
                '''
                swaccess: "rw"
                hwaccess: "hro"
                resval: "1"
            },
          ]
      }

       {
          name: PAD_GPIOB13_MUX_SEL
          desc: '''
              Pad signal port multiplex selection for pad pad_gpiob13. The programmed value defines which port
              is connected to the pad.
          '''
          swaccess: "rw"
          hwaccess: "hro"
          resval: 0
          fields: [
              {
                  name: sel
                  desc: "Port selection index for pad pad_gpiob13."
                  bits: "5:0"
                  enum: [
                      { value: "0", name: "register", desc: "Connects the Pad to the internal configuration register."}
                      { value: "1", name: "port_gpio_b_gpio13", desc: "Connect port gpio13 from port group gpio_b to this pad." }
                      { value: "2", name: "port_qspi0_spi_csn0", desc: "Connect port spi_csn0 from port group qspi0 to this pad." }
                      { value: "3", name: "port_qspi0_spi_csn1", desc: "Connect port spi_csn1 from port group qspi0 to this pad." }
                      { value: "4", name: "port_qspi0_spi_csn2", desc: "Connect port spi_csn2 from port group qspi0 to this pad." }
                      { value: "5", name: "port_qspi0_spi_csn3", desc: "Connect port spi_csn3 from port group qspi0 to this pad." }
                      { value: "6", name: "port_qspi0_spi_sck", desc: "Connect port spi_sck from port group qspi0 to this pad." }
                      { value: "7", name: "port_qspi0_spi_sdio0", desc: "Connect port spi_sdio0 from port group qspi0 to this pad." }
                      { value: "8", name: "port_qspi0_spi_sdio1", desc: "Connect port spi_sdio1 from port group qspi0 to this pad." }
                      { value: "9", name: "port_qspi0_spi_sdio2", desc: "Connect port spi_sdio2 from port group qspi0 to this pad." }
                      { value: "10", name: "port_qspi0_spi_sdio3", desc: "Connect port spi_sdio3 from port group qspi0 to this pad." }
                      { value: "11", name: "port_qspi1_spi_csn0", desc: "Connect port spi_csn0 from port group qspi1 to this pad." }
                      { value: "12", name: "port_qspi1_spi_csn1", desc: "Connect port spi_csn1 from port group qspi1 to this pad." }
                      { value: "13", name: "port_qspi1_spi_csn2", desc: "Connect port spi_csn2 from port group qspi1 to this pad." }
                      { value: "14", name: "port_qspi1_spi_csn3", desc: "Connect port spi_csn3 from port group qspi1 to this pad." }
                      { value: "15", name: "port_qspi1_spi_sck", desc: "Connect port spi_sck from port group qspi1 to this pad." }
                      { value: "16", name: "port_qspi1_spi_sdio0", desc: "Connect port spi_sdio0 from port group qspi1 to this pad." }
                      { value: "17", name: "port_qspi1_spi_sdio1", desc: "Connect port spi_sdio1 from port group qspi1 to this pad." }
                      { value: "18", name: "port_qspi1_spi_sdio2", desc: "Connect port spi_sdio2 from port group qspi1 to this pad." }
                      { value: "19", name: "port_qspi1_spi_sdio3", desc: "Connect port spi_sdio3 from port group qspi1 to this pad." }
                      { value: "20", name: "port_qspi2_spi_csn0", desc: "Connect port spi_csn0 from port group qspi2 to this pad." }
                      { value: "21", name: "port_qspi2_spi_csn1", desc: "Connect port spi_csn1 from port group qspi2 to this pad." }
                      { value: "22", name: "port_qspi2_spi_csn2", desc: "Connect port spi_csn2 from port group qspi2 to this pad." }
                      { value: "23", name: "port_qspi2_spi_csn3", desc: "Connect port spi_csn3 from port group qspi2 to this pad." }
                      { value: "24", name: "port_qspi2_spi_sck", desc: "Connect port spi_sck from port group qspi2 to this pad." }
                      { value: "25", name: "port_qspi2_spi_sdio0", desc: "Connect port spi_sdio0 from port group qspi2 to this pad." }
                      { value: "26", name: "port_qspi2_spi_sdio1", desc: "Connect port spi_sdio1 from port group qspi2 to this pad." }
                      { value: "27", name: "port_qspi2_spi_sdio2", desc: "Connect port spi_sdio2 from port group qspi2 to this pad." }
                      { value: "28", name: "port_qspi2_spi_sdio3", desc: "Connect port spi_sdio3 from port group qspi2 to this pad." }
                      { value: "29", name: "port_qspi3_spi_csn0", desc: "Connect port spi_csn0 from port group qspi3 to this pad." }
                      { value: "30", name: "port_qspi3_spi_csn1", desc: "Connect port spi_csn1 from port group qspi3 to this pad." }
                      { value: "31", name: "port_qspi3_spi_csn2", desc: "Connect port spi_csn2 from port group qspi3 to this pad." }
                      { value: "32", name: "port_qspi3_spi_csn3", desc: "Connect port spi_csn3 from port group qspi3 to this pad." }
                      { value: "33", name: "port_qspi3_spi_sck", desc: "Connect port spi_sck from port group qspi3 to this pad." }
                      { value: "34", name: "port_qspi3_spi_sdio0", desc: "Connect port spi_sdio0 from port group qspi3 to this pad." }
                      { value: "35", name: "port_qspi3_spi_sdio1", desc: "Connect port spi_sdio1 from port group qspi3 to this pad." }
                      { value: "36", name: "port_qspi3_spi_sdio2", desc: "Connect port spi_sdio2 from port group qspi3 to this pad." }
                      { value: "37", name: "port_qspi3_spi_sdio3", desc: "Connect port spi_sdio3 from port group qspi3 to this pad." }
                      { value: "38", name: "port_timer0_out0", desc: "Connect port out0 from port group timer0 to this pad." }
                      { value: "39", name: "port_timer0_out1", desc: "Connect port out1 from port group timer0 to this pad." }
                      { value: "40", name: "port_timer0_out2", desc: "Connect port out2 from port group timer0 to this pad." }
                      { value: "41", name: "port_timer0_out3", desc: "Connect port out3 from port group timer0 to this pad." }
                      { value: "42", name: "port_timer1_out0", desc: "Connect port out0 from port group timer1 to this pad." }
                      { value: "43", name: "port_timer1_out1", desc: "Connect port out1 from port group timer1 to this pad." }
                      { value: "44", name: "port_timer1_out2", desc: "Connect port out2 from port group timer1 to this pad." }
                      { value: "45", name: "port_timer1_out3", desc: "Connect port out3 from port group timer1 to this pad." }
                      { value: "46", name: "port_timer2_out0", desc: "Connect port out0 from port group timer2 to this pad." }
                      { value: "47", name: "port_timer2_out1", desc: "Connect port out1 from port group timer2 to this pad." }
                      { value: "48", name: "port_timer2_out2", desc: "Connect port out2 from port group timer2 to this pad." }
                      { value: "49", name: "port_timer2_out3", desc: "Connect port out3 from port group timer2 to this pad." }
                      { value: "50", name: "port_timer3_out0", desc: "Connect port out0 from port group timer3 to this pad." }
                      { value: "51", name: "port_timer3_out1", desc: "Connect port out1 from port group timer3 to this pad." }
                      { value: "52", name: "port_timer3_out2", desc: "Connect port out2 from port group timer3 to this pad." }
                      { value: "53", name: "port_timer3_out3", desc: "Connect port out3 from port group timer3 to this pad." }
                  ]
              }
          ]
      }

      {
          name: PAD_GPIOB14_CFG
          desc: '''
            Pad signal configuration.
          '''
          swaccess: "rw"
          fields: [
            {
                bits: "0"
                name: chip2pad
                desc: '''
                     The signal that connects to the pads TX driver
                '''
                swaccess: "rw"
                hwaccess: "hro"
                resval: "0"
            },
            {
                bits: "2:1"
                name: drv
                desc: '''
                     Driving strength selector
                '''
                swaccess: "rw"
                hwaccess: "hro"
                resval: "3"
            },
            {
                bits: "3"
                name: pde
                desc: '''
                     Pull down resistor enable
                '''
                swaccess: "rw"
                hwaccess: "hro"
                resval: "0"
            },
            {
                bits: "4"
                name: pue
                desc: '''
                     Pull up resistor enable
                '''
                swaccess: "rw"
                hwaccess: "hro"
                resval: "0"
            },
            {
                bits: "5"
                name: rxe
                desc: '''
                     Active high RX driver enable 
                '''
                swaccess: "rw"
                hwaccess: "hro"
                resval: "1"
            },
            {
                bits: "6"
                name: slw
                desc: '''
                     
                '''
                swaccess: "rw"
                hwaccess: "hro"
                resval: "0"
            },
            {
                bits: "7"
                name: smt
                desc: '''
                     Schmit trigger enable
                '''
                swaccess: "rw"
                hwaccess: "hro"
                resval: "0"
            },
            {
                bits: "8"
                name: trie
                desc: '''
                      Active high tri-state enable (active low TX driver enable)
                '''
                swaccess: "rw"
                hwaccess: "hro"
                resval: "1"
            },
          ]
      }

       {
          name: PAD_GPIOB14_MUX_SEL
          desc: '''
              Pad signal port multiplex selection for pad pad_gpiob14. The programmed value defines which port
              is connected to the pad.
          '''
          swaccess: "rw"
          hwaccess: "hro"
          resval: 0
          fields: [
              {
                  name: sel
                  desc: "Port selection index for pad pad_gpiob14."
                  bits: "5:0"
                  enum: [
                      { value: "0", name: "register", desc: "Connects the Pad to the internal configuration register."}
                      { value: "1", name: "port_gpio_b_gpio14", desc: "Connect port gpio14 from port group gpio_b to this pad." }
                      { value: "2", name: "port_qspi0_spi_csn0", desc: "Connect port spi_csn0 from port group qspi0 to this pad." }
                      { value: "3", name: "port_qspi0_spi_csn1", desc: "Connect port spi_csn1 from port group qspi0 to this pad." }
                      { value: "4", name: "port_qspi0_spi_csn2", desc: "Connect port spi_csn2 from port group qspi0 to this pad." }
                      { value: "5", name: "port_qspi0_spi_csn3", desc: "Connect port spi_csn3 from port group qspi0 to this pad." }
                      { value: "6", name: "port_qspi0_spi_sck", desc: "Connect port spi_sck from port group qspi0 to this pad." }
                      { value: "7", name: "port_qspi0_spi_sdio0", desc: "Connect port spi_sdio0 from port group qspi0 to this pad." }
                      { value: "8", name: "port_qspi0_spi_sdio1", desc: "Connect port spi_sdio1 from port group qspi0 to this pad." }
                      { value: "9", name: "port_qspi0_spi_sdio2", desc: "Connect port spi_sdio2 from port group qspi0 to this pad." }
                      { value: "10", name: "port_qspi0_spi_sdio3", desc: "Connect port spi_sdio3 from port group qspi0 to this pad." }
                      { value: "11", name: "port_qspi1_spi_csn0", desc: "Connect port spi_csn0 from port group qspi1 to this pad." }
                      { value: "12", name: "port_qspi1_spi_csn1", desc: "Connect port spi_csn1 from port group qspi1 to this pad." }
                      { value: "13", name: "port_qspi1_spi_csn2", desc: "Connect port spi_csn2 from port group qspi1 to this pad." }
                      { value: "14", name: "port_qspi1_spi_csn3", desc: "Connect port spi_csn3 from port group qspi1 to this pad." }
                      { value: "15", name: "port_qspi1_spi_sck", desc: "Connect port spi_sck from port group qspi1 to this pad." }
                      { value: "16", name: "port_qspi1_spi_sdio0", desc: "Connect port spi_sdio0 from port group qspi1 to this pad." }
                      { value: "17", name: "port_qspi1_spi_sdio1", desc: "Connect port spi_sdio1 from port group qspi1 to this pad." }
                      { value: "18", name: "port_qspi1_spi_sdio2", desc: "Connect port spi_sdio2 from port group qspi1 to this pad." }
                      { value: "19", name: "port_qspi1_spi_sdio3", desc: "Connect port spi_sdio3 from port group qspi1 to this pad." }
                      { value: "20", name: "port_qspi2_spi_csn0", desc: "Connect port spi_csn0 from port group qspi2 to this pad." }
                      { value: "21", name: "port_qspi2_spi_csn1", desc: "Connect port spi_csn1 from port group qspi2 to this pad." }
                      { value: "22", name: "port_qspi2_spi_csn2", desc: "Connect port spi_csn2 from port group qspi2 to this pad." }
                      { value: "23", name: "port_qspi2_spi_csn3", desc: "Connect port spi_csn3 from port group qspi2 to this pad." }
                      { value: "24", name: "port_qspi2_spi_sck", desc: "Connect port spi_sck from port group qspi2 to this pad." }
                      { value: "25", name: "port_qspi2_spi_sdio0", desc: "Connect port spi_sdio0 from port group qspi2 to this pad." }
                      { value: "26", name: "port_qspi2_spi_sdio1", desc: "Connect port spi_sdio1 from port group qspi2 to this pad." }
                      { value: "27", name: "port_qspi2_spi_sdio2", desc: "Connect port spi_sdio2 from port group qspi2 to this pad." }
                      { value: "28", name: "port_qspi2_spi_sdio3", desc: "Connect port spi_sdio3 from port group qspi2 to this pad." }
                      { value: "29", name: "port_qspi3_spi_csn0", desc: "Connect port spi_csn0 from port group qspi3 to this pad." }
                      { value: "30", name: "port_qspi3_spi_csn1", desc: "Connect port spi_csn1 from port group qspi3 to this pad." }
                      { value: "31", name: "port_qspi3_spi_csn2", desc: "Connect port spi_csn2 from port group qspi3 to this pad." }
                      { value: "32", name: "port_qspi3_spi_csn3", desc: "Connect port spi_csn3 from port group qspi3 to this pad." }
                      { value: "33", name: "port_qspi3_spi_sck", desc: "Connect port spi_sck from port group qspi3 to this pad." }
                      { value: "34", name: "port_qspi3_spi_sdio0", desc: "Connect port spi_sdio0 from port group qspi3 to this pad." }
                      { value: "35", name: "port_qspi3_spi_sdio1", desc: "Connect port spi_sdio1 from port group qspi3 to this pad." }
                      { value: "36", name: "port_qspi3_spi_sdio2", desc: "Connect port spi_sdio2 from port group qspi3 to this pad." }
                      { value: "37", name: "port_qspi3_spi_sdio3", desc: "Connect port spi_sdio3 from port group qspi3 to this pad." }
                      { value: "38", name: "port_timer0_out0", desc: "Connect port out0 from port group timer0 to this pad." }
                      { value: "39", name: "port_timer0_out1", desc: "Connect port out1 from port group timer0 to this pad." }
                      { value: "40", name: "port_timer0_out2", desc: "Connect port out2 from port group timer0 to this pad." }
                      { value: "41", name: "port_timer0_out3", desc: "Connect port out3 from port group timer0 to this pad." }
                      { value: "42", name: "port_timer1_out0", desc: "Connect port out0 from port group timer1 to this pad." }
                      { value: "43", name: "port_timer1_out1", desc: "Connect port out1 from port group timer1 to this pad." }
                      { value: "44", name: "port_timer1_out2", desc: "Connect port out2 from port group timer1 to this pad." }
                      { value: "45", name: "port_timer1_out3", desc: "Connect port out3 from port group timer1 to this pad." }
                      { value: "46", name: "port_timer2_out0", desc: "Connect port out0 from port group timer2 to this pad." }
                      { value: "47", name: "port_timer2_out1", desc: "Connect port out1 from port group timer2 to this pad." }
                      { value: "48", name: "port_timer2_out2", desc: "Connect port out2 from port group timer2 to this pad." }
                      { value: "49", name: "port_timer2_out3", desc: "Connect port out3 from port group timer2 to this pad." }
                      { value: "50", name: "port_timer3_out0", desc: "Connect port out0 from port group timer3 to this pad." }
                      { value: "51", name: "port_timer3_out1", desc: "Connect port out1 from port group timer3 to this pad." }
                      { value: "52", name: "port_timer3_out2", desc: "Connect port out2 from port group timer3 to this pad." }
                      { value: "53", name: "port_timer3_out3", desc: "Connect port out3 from port group timer3 to this pad." }
                  ]
              }
          ]
      }

      {
          name: PAD_GPIOB15_CFG
          desc: '''
            Pad signal configuration.
          '''
          swaccess: "rw"
          fields: [
            {
                bits: "0"
                name: chip2pad
                desc: '''
                     The signal that connects to the pads TX driver
                '''
                swaccess: "rw"
                hwaccess: "hro"
                resval: "0"
            },
            {
                bits: "2:1"
                name: drv
                desc: '''
                     Driving strength selector
                '''
                swaccess: "rw"
                hwaccess: "hro"
                resval: "3"
            },
            {
                bits: "3"
                name: pde
                desc: '''
                     Pull down resistor enable
                '''
                swaccess: "rw"
                hwaccess: "hro"
                resval: "0"
            },
            {
                bits: "4"
                name: pue
                desc: '''
                     Pull up resistor enable
                '''
                swaccess: "rw"
                hwaccess: "hro"
                resval: "0"
            },
            {
                bits: "5"
                name: rxe
                desc: '''
                     Active high RX driver enable 
                '''
                swaccess: "rw"
                hwaccess: "hro"
                resval: "1"
            },
            {
                bits: "6"
                name: slw
                desc: '''
                     
                '''
                swaccess: "rw"
                hwaccess: "hro"
                resval: "0"
            },
            {
                bits: "7"
                name: smt
                desc: '''
                     Schmit trigger enable
                '''
                swaccess: "rw"
                hwaccess: "hro"
                resval: "0"
            },
            {
                bits: "8"
                name: trie
                desc: '''
                      Active high tri-state enable (active low TX driver enable)
                '''
                swaccess: "rw"
                hwaccess: "hro"
                resval: "1"
            },
          ]
      }

       {
          name: PAD_GPIOB15_MUX_SEL
          desc: '''
              Pad signal port multiplex selection for pad pad_gpiob15. The programmed value defines which port
              is connected to the pad.
          '''
          swaccess: "rw"
          hwaccess: "hro"
          resval: 0
          fields: [
              {
                  name: sel
                  desc: "Port selection index for pad pad_gpiob15."
                  bits: "5:0"
                  enum: [
                      { value: "0", name: "register", desc: "Connects the Pad to the internal configuration register."}
                      { value: "1", name: "port_gpio_b_gpio15", desc: "Connect port gpio15 from port group gpio_b to this pad." }
                      { value: "2", name: "port_qspi0_spi_csn0", desc: "Connect port spi_csn0 from port group qspi0 to this pad." }
                      { value: "3", name: "port_qspi0_spi_csn1", desc: "Connect port spi_csn1 from port group qspi0 to this pad." }
                      { value: "4", name: "port_qspi0_spi_csn2", desc: "Connect port spi_csn2 from port group qspi0 to this pad." }
                      { value: "5", name: "port_qspi0_spi_csn3", desc: "Connect port spi_csn3 from port group qspi0 to this pad." }
                      { value: "6", name: "port_qspi0_spi_sck", desc: "Connect port spi_sck from port group qspi0 to this pad." }
                      { value: "7", name: "port_qspi0_spi_sdio0", desc: "Connect port spi_sdio0 from port group qspi0 to this pad." }
                      { value: "8", name: "port_qspi0_spi_sdio1", desc: "Connect port spi_sdio1 from port group qspi0 to this pad." }
                      { value: "9", name: "port_qspi0_spi_sdio2", desc: "Connect port spi_sdio2 from port group qspi0 to this pad." }
                      { value: "10", name: "port_qspi0_spi_sdio3", desc: "Connect port spi_sdio3 from port group qspi0 to this pad." }
                      { value: "11", name: "port_qspi1_spi_csn0", desc: "Connect port spi_csn0 from port group qspi1 to this pad." }
                      { value: "12", name: "port_qspi1_spi_csn1", desc: "Connect port spi_csn1 from port group qspi1 to this pad." }
                      { value: "13", name: "port_qspi1_spi_csn2", desc: "Connect port spi_csn2 from port group qspi1 to this pad." }
                      { value: "14", name: "port_qspi1_spi_csn3", desc: "Connect port spi_csn3 from port group qspi1 to this pad." }
                      { value: "15", name: "port_qspi1_spi_sck", desc: "Connect port spi_sck from port group qspi1 to this pad." }
                      { value: "16", name: "port_qspi1_spi_sdio0", desc: "Connect port spi_sdio0 from port group qspi1 to this pad." }
                      { value: "17", name: "port_qspi1_spi_sdio1", desc: "Connect port spi_sdio1 from port group qspi1 to this pad." }
                      { value: "18", name: "port_qspi1_spi_sdio2", desc: "Connect port spi_sdio2 from port group qspi1 to this pad." }
                      { value: "19", name: "port_qspi1_spi_sdio3", desc: "Connect port spi_sdio3 from port group qspi1 to this pad." }
                      { value: "20", name: "port_qspi2_spi_csn0", desc: "Connect port spi_csn0 from port group qspi2 to this pad." }
                      { value: "21", name: "port_qspi2_spi_csn1", desc: "Connect port spi_csn1 from port group qspi2 to this pad." }
                      { value: "22", name: "port_qspi2_spi_csn2", desc: "Connect port spi_csn2 from port group qspi2 to this pad." }
                      { value: "23", name: "port_qspi2_spi_csn3", desc: "Connect port spi_csn3 from port group qspi2 to this pad." }
                      { value: "24", name: "port_qspi2_spi_sck", desc: "Connect port spi_sck from port group qspi2 to this pad." }
                      { value: "25", name: "port_qspi2_spi_sdio0", desc: "Connect port spi_sdio0 from port group qspi2 to this pad." }
                      { value: "26", name: "port_qspi2_spi_sdio1", desc: "Connect port spi_sdio1 from port group qspi2 to this pad." }
                      { value: "27", name: "port_qspi2_spi_sdio2", desc: "Connect port spi_sdio2 from port group qspi2 to this pad." }
                      { value: "28", name: "port_qspi2_spi_sdio3", desc: "Connect port spi_sdio3 from port group qspi2 to this pad." }
                      { value: "29", name: "port_qspi3_spi_csn0", desc: "Connect port spi_csn0 from port group qspi3 to this pad." }
                      { value: "30", name: "port_qspi3_spi_csn1", desc: "Connect port spi_csn1 from port group qspi3 to this pad." }
                      { value: "31", name: "port_qspi3_spi_csn2", desc: "Connect port spi_csn2 from port group qspi3 to this pad." }
                      { value: "32", name: "port_qspi3_spi_csn3", desc: "Connect port spi_csn3 from port group qspi3 to this pad." }
                      { value: "33", name: "port_qspi3_spi_sck", desc: "Connect port spi_sck from port group qspi3 to this pad." }
                      { value: "34", name: "port_qspi3_spi_sdio0", desc: "Connect port spi_sdio0 from port group qspi3 to this pad." }
                      { value: "35", name: "port_qspi3_spi_sdio1", desc: "Connect port spi_sdio1 from port group qspi3 to this pad." }
                      { value: "36", name: "port_qspi3_spi_sdio2", desc: "Connect port spi_sdio2 from port group qspi3 to this pad." }
                      { value: "37", name: "port_qspi3_spi_sdio3", desc: "Connect port spi_sdio3 from port group qspi3 to this pad." }
                      { value: "38", name: "port_timer0_out0", desc: "Connect port out0 from port group timer0 to this pad." }
                      { value: "39", name: "port_timer0_out1", desc: "Connect port out1 from port group timer0 to this pad." }
                      { value: "40", name: "port_timer0_out2", desc: "Connect port out2 from port group timer0 to this pad." }
                      { value: "41", name: "port_timer0_out3", desc: "Connect port out3 from port group timer0 to this pad." }
                      { value: "42", name: "port_timer1_out0", desc: "Connect port out0 from port group timer1 to this pad." }
                      { value: "43", name: "port_timer1_out1", desc: "Connect port out1 from port group timer1 to this pad." }
                      { value: "44", name: "port_timer1_out2", desc: "Connect port out2 from port group timer1 to this pad." }
                      { value: "45", name: "port_timer1_out3", desc: "Connect port out3 from port group timer1 to this pad." }
                      { value: "46", name: "port_timer2_out0", desc: "Connect port out0 from port group timer2 to this pad." }
                      { value: "47", name: "port_timer2_out1", desc: "Connect port out1 from port group timer2 to this pad." }
                      { value: "48", name: "port_timer2_out2", desc: "Connect port out2 from port group timer2 to this pad." }
                      { value: "49", name: "port_timer2_out3", desc: "Connect port out3 from port group timer2 to this pad." }
                      { value: "50", name: "port_timer3_out0", desc: "Connect port out0 from port group timer3 to this pad." }
                      { value: "51", name: "port_timer3_out1", desc: "Connect port out1 from port group timer3 to this pad." }
                      { value: "52", name: "port_timer3_out2", desc: "Connect port out2 from port group timer3 to this pad." }
                      { value: "53", name: "port_timer3_out3", desc: "Connect port out3 from port group timer3 to this pad." }
                  ]
              }
          ]
      }

    ]
}
